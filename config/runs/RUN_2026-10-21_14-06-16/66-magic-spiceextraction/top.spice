* NGSPICE file created from top.ext - technology: sky130A

* Black-box entry subcircuit for sky130_fd_sc_hd__tapvpwrvgnd_1 abstract view
.subckt sky130_fd_sc_hd__tapvpwrvgnd_1 VGND VPWR
.ends

* Black-box entry subcircuit for sky130_fd_sc_hd__a21o_1 abstract view
.subckt sky130_fd_sc_hd__a21o_1 A1 A2 B1 VGND VNB VPB VPWR X
.ends

* Black-box entry subcircuit for sky130_fd_sc_hd__decap_3 abstract view
.subckt sky130_fd_sc_hd__decap_3 VGND VNB VPB VPWR
.ends

* Black-box entry subcircuit for sky130_fd_sc_hd__nand2_1 abstract view
.subckt sky130_fd_sc_hd__nand2_1 A B VGND VNB VPB VPWR Y
.ends

* Black-box entry subcircuit for sky130_fd_sc_hd__fill_1 abstract view
.subckt sky130_fd_sc_hd__fill_1 VGND VNB VPB VPWR
.ends

* Black-box entry subcircuit for sky130_fd_sc_hd__decap_6 abstract view
.subckt sky130_fd_sc_hd__decap_6 VGND VNB VPB VPWR
.ends

* Black-box entry subcircuit for sky130_fd_sc_hd__dfrtp_1 abstract view
.subckt sky130_fd_sc_hd__dfrtp_1 CLK D RESET_B VGND VNB VPB VPWR Q
.ends

* Black-box entry subcircuit for sky130_fd_sc_hd__decap_4 abstract view
.subckt sky130_fd_sc_hd__decap_4 VGND VNB VPB VPWR
.ends

* Black-box entry subcircuit for sky130_fd_sc_hd__a32o_1 abstract view
.subckt sky130_fd_sc_hd__a32o_1 A1 A2 A3 B1 B2 VGND VNB VPB VPWR X
.ends

* Black-box entry subcircuit for sky130_fd_sc_hd__fill_2 abstract view
.subckt sky130_fd_sc_hd__fill_2 VGND VNB VPB VPWR
.ends

* Black-box entry subcircuit for sky130_fd_sc_hd__a21oi_1 abstract view
.subckt sky130_fd_sc_hd__a21oi_1 A1 A2 B1 VGND VNB VPB VPWR Y
.ends

* Black-box entry subcircuit for sky130_ef_sc_hd__decap_12 abstract view
.subckt sky130_ef_sc_hd__decap_12 VPWR VGND VPB VNB
.ends

* Black-box entry subcircuit for sky130_fd_sc_hd__and2_1 abstract view
.subckt sky130_fd_sc_hd__and2_1 A B VGND VNB VPB VPWR X
.ends

* Black-box entry subcircuit for sky130_fd_sc_hd__decap_8 abstract view
.subckt sky130_fd_sc_hd__decap_8 VGND VNB VPB VPWR
.ends

* Black-box entry subcircuit for sky130_fd_sc_hd__dlygate4sd3_1 abstract view
.subckt sky130_fd_sc_hd__dlygate4sd3_1 A VGND VNB VPB VPWR X
.ends

* Black-box entry subcircuit for sky130_fd_sc_hd__buf_1 abstract view
.subckt sky130_fd_sc_hd__buf_1 A VGND VNB VPB VPWR X
.ends

* Black-box entry subcircuit for sky130_fd_sc_hd__o221a_1 abstract view
.subckt sky130_fd_sc_hd__o221a_1 A1 A2 B1 B2 C1 VGND VNB VPB VPWR X
.ends

* Black-box entry subcircuit for sky130_fd_sc_hd__inv_2 abstract view
.subckt sky130_fd_sc_hd__inv_2 A VGND VNB VPB VPWR Y
.ends

* Black-box entry subcircuit for sky130_fd_sc_hd__clkbuf_16 abstract view
.subckt sky130_fd_sc_hd__clkbuf_16 A VGND VNB VPB VPWR X
.ends

* Black-box entry subcircuit for sky130_fd_sc_hd__o21ai_1 abstract view
.subckt sky130_fd_sc_hd__o21ai_1 A1 A2 B1 VGND VNB VPB VPWR Y
.ends

* Black-box entry subcircuit for sky130_fd_sc_hd__or2_1 abstract view
.subckt sky130_fd_sc_hd__or2_1 A B VGND VNB VPB VPWR X
.ends

* Black-box entry subcircuit for sky130_fd_sc_hd__and4_1 abstract view
.subckt sky130_fd_sc_hd__and4_1 A B C D VGND VNB VPB VPWR X
.ends

* Black-box entry subcircuit for sky130_fd_sc_hd__xnor2_2 abstract view
.subckt sky130_fd_sc_hd__xnor2_2 A B VGND VNB VPB VPWR Y
.ends

* Black-box entry subcircuit for sky130_fd_sc_hd__nor3_1 abstract view
.subckt sky130_fd_sc_hd__nor3_1 A B C VGND VNB VPB VPWR Y
.ends

* Black-box entry subcircuit for sky130_fd_sc_hd__mux2_1 abstract view
.subckt sky130_fd_sc_hd__mux2_1 A0 A1 S VGND VNB VPB VPWR X
.ends

* Black-box entry subcircuit for sky130_fd_sc_hd__a221o_1 abstract view
.subckt sky130_fd_sc_hd__a221o_1 A1 A2 B1 B2 C1 VGND VNB VPB VPWR X
.ends

* Black-box entry subcircuit for sky130_fd_sc_hd__nand3_1 abstract view
.subckt sky130_fd_sc_hd__nand3_1 A B C VGND VNB VPB VPWR Y
.ends

* Black-box entry subcircuit for sky130_fd_sc_hd__and3_2 abstract view
.subckt sky130_fd_sc_hd__and3_2 A B C VGND VNB VPB VPWR X
.ends

* Black-box entry subcircuit for sky130_fd_sc_hd__and3b_2 abstract view
.subckt sky130_fd_sc_hd__and3b_2 A_N B C VGND VNB VPB VPWR X
.ends

* Black-box entry subcircuit for sky130_fd_sc_hd__and3_1 abstract view
.subckt sky130_fd_sc_hd__and3_1 A B C VGND VNB VPB VPWR X
.ends

* Black-box entry subcircuit for sky130_fd_sc_hd__and3b_1 abstract view
.subckt sky130_fd_sc_hd__and3b_1 A_N B C VGND VNB VPB VPWR X
.ends

* Black-box entry subcircuit for sky130_fd_sc_hd__and2b_1 abstract view
.subckt sky130_fd_sc_hd__and2b_1 A_N B VGND VNB VPB VPWR X
.ends

* Black-box entry subcircuit for sky130_fd_sc_hd__a21oi_4 abstract view
.subckt sky130_fd_sc_hd__a21oi_4 A1 A2 B1 VGND VNB VPB VPWR Y
.ends

* Black-box entry subcircuit for sky130_fd_sc_hd__nor2_1 abstract view
.subckt sky130_fd_sc_hd__nor2_1 A B VGND VNB VPB VPWR Y
.ends

* Black-box entry subcircuit for sky130_fd_sc_hd__bufinv_16 abstract view
.subckt sky130_fd_sc_hd__bufinv_16 A VGND VNB VPB VPWR Y
.ends

* Black-box entry subcircuit for sky130_fd_sc_hd__nor3_2 abstract view
.subckt sky130_fd_sc_hd__nor3_2 A B C VGND VNB VPB VPWR Y
.ends

* Black-box entry subcircuit for sky130_fd_sc_hd__a41o_1 abstract view
.subckt sky130_fd_sc_hd__a41o_1 A1 A2 A3 A4 B1 VGND VNB VPB VPWR X
.ends

* Black-box entry subcircuit for sky130_fd_sc_hd__o21a_1 abstract view
.subckt sky130_fd_sc_hd__o21a_1 A1 A2 B1 VGND VNB VPB VPWR X
.ends

* Black-box entry subcircuit for sky130_fd_sc_hd__o2bb2a_1 abstract view
.subckt sky130_fd_sc_hd__o2bb2a_1 A1_N A2_N B1 B2 VGND VNB VPB VPWR X
.ends

* Black-box entry subcircuit for sky130_fd_sc_hd__clkbuf_8 abstract view
.subckt sky130_fd_sc_hd__clkbuf_8 A VGND VNB VPB VPWR X
.ends

* Black-box entry subcircuit for sky130_fd_sc_hd__clkinvlp_4 abstract view
.subckt sky130_fd_sc_hd__clkinvlp_4 A VGND VNB VPB VPWR Y
.ends

* Black-box entry subcircuit for sky130_fd_sc_hd__dfrtp_4 abstract view
.subckt sky130_fd_sc_hd__dfrtp_4 CLK D RESET_B VGND VNB VPB VPWR Q
.ends

* Black-box entry subcircuit for sky130_fd_sc_hd__clkinv_4 abstract view
.subckt sky130_fd_sc_hd__clkinv_4 A VGND VNB VPB VPWR Y
.ends

* Black-box entry subcircuit for sky130_fd_sc_hd__o31a_1 abstract view
.subckt sky130_fd_sc_hd__o31a_1 A1 A2 A3 B1 VGND VNB VPB VPWR X
.ends

* Black-box entry subcircuit for sky130_fd_sc_hd__dfrtp_2 abstract view
.subckt sky130_fd_sc_hd__dfrtp_2 CLK D RESET_B VGND VNB VPB VPWR Q
.ends

* Black-box entry subcircuit for sky130_fd_sc_hd__a211o_1 abstract view
.subckt sky130_fd_sc_hd__a211o_1 A1 A2 B1 C1 VGND VNB VPB VPWR X
.ends

* Black-box entry subcircuit for sky130_fd_sc_hd__o221a_2 abstract view
.subckt sky130_fd_sc_hd__o221a_2 A1 A2 B1 B2 C1 VGND VNB VPB VPWR X
.ends

* Black-box entry subcircuit for sky130_fd_sc_hd__and4_2 abstract view
.subckt sky130_fd_sc_hd__and4_2 A B C D VGND VNB VPB VPWR X
.ends

* Black-box entry subcircuit for sky130_fd_sc_hd__a31o_1 abstract view
.subckt sky130_fd_sc_hd__a31o_1 A1 A2 A3 B1 VGND VNB VPB VPWR X
.ends

* Black-box entry subcircuit for sky130_fd_sc_hd__buf_2 abstract view
.subckt sky130_fd_sc_hd__buf_2 A VGND VNB VPB VPWR X
.ends

* Black-box entry subcircuit for sky130_fd_sc_hd__clkbuf_1 abstract view
.subckt sky130_fd_sc_hd__clkbuf_1 A VGND VNB VPB VPWR X
.ends

* Black-box entry subcircuit for sky130_fd_sc_hd__nand2b_1 abstract view
.subckt sky130_fd_sc_hd__nand2b_1 A_N B VGND VNB VPB VPWR Y
.ends

* Black-box entry subcircuit for sky130_fd_sc_hd__xor2_4 abstract view
.subckt sky130_fd_sc_hd__xor2_4 A B VGND VNB VPB VPWR X
.ends

* Black-box entry subcircuit for sky130_fd_sc_hd__buf_12 abstract view
.subckt sky130_fd_sc_hd__buf_12 A VGND VNB VPB VPWR X
.ends

* Black-box entry subcircuit for sky130_fd_sc_hd__a31oi_1 abstract view
.subckt sky130_fd_sc_hd__a31oi_1 A1 A2 A3 B1 VGND VNB VPB VPWR Y
.ends

* Black-box entry subcircuit for sky130_fd_sc_hd__nand4_1 abstract view
.subckt sky130_fd_sc_hd__nand4_1 A B C D VGND VNB VPB VPWR Y
.ends

* Black-box entry subcircuit for sky130_fd_sc_hd__and4bb_1 abstract view
.subckt sky130_fd_sc_hd__and4bb_1 A_N B_N C D VGND VNB VPB VPWR X
.ends

* Black-box entry subcircuit for sky130_fd_sc_hd__nor3b_1 abstract view
.subckt sky130_fd_sc_hd__nor3b_1 A B C_N VGND VNB VPB VPWR Y
.ends

* Black-box entry subcircuit for sky130_fd_sc_hd__or3b_1 abstract view
.subckt sky130_fd_sc_hd__or3b_1 A B C_N VGND VNB VPB VPWR X
.ends

* Black-box entry subcircuit for sky130_fd_sc_hd__or3_1 abstract view
.subckt sky130_fd_sc_hd__or3_1 A B C VGND VNB VPB VPWR X
.ends

* Black-box entry subcircuit for sky130_fd_sc_hd__or2_2 abstract view
.subckt sky130_fd_sc_hd__or2_2 A B VGND VNB VPB VPWR X
.ends

* Black-box entry subcircuit for sky130_fd_sc_hd__or4_1 abstract view
.subckt sky130_fd_sc_hd__or4_1 A B C D VGND VNB VPB VPWR X
.ends

* Black-box entry subcircuit for sky130_fd_sc_hd__nor2_4 abstract view
.subckt sky130_fd_sc_hd__nor2_4 A B VGND VNB VPB VPWR Y
.ends

* Black-box entry subcircuit for sky130_fd_sc_hd__or3b_2 abstract view
.subckt sky130_fd_sc_hd__or3b_2 A B C_N VGND VNB VPB VPWR X
.ends

* Black-box entry subcircuit for sky130_fd_sc_hd__a2bb2o_1 abstract view
.subckt sky130_fd_sc_hd__a2bb2o_1 A1_N A2_N B1 B2 VGND VNB VPB VPWR X
.ends

.subckt top VGND VPWR alarm_short bad_cnt[0] bad_cnt[1] bad_cnt[2] bad_cnt[3] bad_cnt[4]
+ bad_cnt[5] bad_cnt[6] bad_cnt[7] buzzer clear_log clk good_cnt[0] good_cnt[1] good_cnt[2]
+ good_cnt[3] good_cnt[4] good_cnt[5] good_cnt[6] good_cnt[7] led_done led_progress[0]
+ led_progress[1] led_progress[2] mode_sel[0] mode_sel[1] rst_n sensor_in
XTAP_TAPCELL_ROW_32_183 VGND VPWR sky130_fd_sc_hd__tapvpwrvgnd_1
XTAP_TAPCELL_ROW_9_104 VGND VPWR sky130_fd_sc_hd__tapvpwrvgnd_1
X_294_ u_fsm.secs\[3\] _122_ u_fsm.secs\[4\] VGND VGND VPWR VPWR _124_ sky130_fd_sc_hd__a21o_1
XFILLER_26_85 VGND VGND VPWR VPWR sky130_fd_sc_hd__decap_3
X_363_ net20 _172_ VGND VGND VPWR VPWR _174_ sky130_fd_sc_hd__nand2_1
XFILLER_13_177 VGND VGND VPWR VPWR sky130_fd_sc_hd__fill_1
XFILLER_13_133 VGND VGND VPWR VPWR sky130_fd_sc_hd__decap_6
XFILLER_13_111 VGND VGND VPWR VPWR sky130_fd_sc_hd__fill_1
X_432_ clknet_3_0__leaf_clk _005_ net4 VGND VGND VPWR VPWR u_deb.cnt\[4\] sky130_fd_sc_hd__dfrtp_1
XFILLER_9_126 VGND VGND VPWR VPWR sky130_fd_sc_hd__decap_4
XTAP_TAPCELL_ROW_20_142 VGND VPWR sky130_fd_sc_hd__tapvpwrvgnd_1
XPHY_EDGE_ROW_0_Left_34 VGND VGND VPWR VPWR sky130_fd_sc_hd__decap_3
X_346_ _151_ _162_ _163_ _161_ net64 VGND VGND VPWR VPWR _036_ sky130_fd_sc_hd__a32o_1
XFILLER_6_118 VGND VGND VPWR VPWR sky130_fd_sc_hd__fill_2
XTAP_TAPCELL_ROW_8_99 VGND VPWR sky130_fd_sc_hd__tapvpwrvgnd_1
X_415_ clknet_3_2__leaf_clk _032_ net4 VGND VGND VPWR VPWR u_fsm.aux\[3\] sky130_fd_sc_hd__dfrtp_1
X_277_ net51 _109_ _110_ VGND VGND VPWR VPWR _016_ sky130_fd_sc_hd__a21oi_1
XFILLER_23_53 VGND VGND VPWR VPWR sky130_fd_sc_hd__decap_3
XFILLER_0_57 VPWR VGND VPWR VGND sky130_ef_sc_hd__decap_12
X_329_ net34 _146_ VGND VGND VPWR VPWR _032_ sky130_fd_sc_hd__and2_1
XFILLER_18_64 VGND VGND VPWR VPWR sky130_fd_sc_hd__decap_8
XTAP_TAPCELL_ROW_5_89 VGND VPWR sky130_fd_sc_hd__tapvpwrvgnd_1
XFILLER_28_150 VGND VGND VPWR VPWR sky130_fd_sc_hd__decap_8
Xhold30 u_tick.cnt\[9\] VGND VGND VPWR VPWR net57 sky130_fd_sc_hd__dlygate4sd3_1
XFILLER_26_109 VGND VGND VPWR VPWR sky130_fd_sc_hd__fill_1
XFILLER_13_3 VPWR VGND VPWR VGND sky130_ef_sc_hd__decap_12
XFILLER_6_45 VGND VGND VPWR VPWR sky130_fd_sc_hd__fill_1
XFILLER_31_167 VGND VGND VPWR VPWR sky130_fd_sc_hd__fill_1
XFILLER_31_134 VGND VGND VPWR VPWR sky130_fd_sc_hd__decap_6
Xoutput20 net20 VGND VGND VPWR VPWR good_cnt[4] sky130_fd_sc_hd__buf_1
XTAP_TAPCELL_ROW_18_137 VGND VPWR sky130_fd_sc_hd__tapvpwrvgnd_1
XFILLER_16_197 VGND VGND VPWR VPWR sky130_fd_sc_hd__fill_2
XFILLER_16_153 VGND VGND VPWR VPWR sky130_fd_sc_hd__decap_6
XTAP_TAPCELL_ROW_2_79 VGND VPWR sky130_fd_sc_hd__tapvpwrvgnd_1
Xoutput7 net7 VGND VGND VPWR VPWR bad_cnt[0] sky130_fd_sc_hd__buf_1
XTAP_TAPCELL_ROW_32_184 VGND VPWR sky130_fd_sc_hd__tapvpwrvgnd_1
XTAP_TAPCELL_ROW_9_105 VGND VPWR sky130_fd_sc_hd__tapvpwrvgnd_1
X_293_ u_fsm.secs\[2\] _120_ _122_ u_fsm.secs\[3\] _121_ VGND VGND VPWR VPWR _123_
+ sky130_fd_sc_hd__o221a_1
X_362_ _172_ VGND VGND VPWR VPWR _173_ sky130_fd_sc_hd__inv_2
Xclkbuf_3_6__f_clk clknet_0_clk VGND VGND VPWR VPWR clknet_3_6__leaf_clk sky130_fd_sc_hd__clkbuf_16
XFILLER_13_167 VGND VGND VPWR VPWR sky130_fd_sc_hd__fill_1
X_431_ clknet_3_0__leaf_clk _004_ net4 VGND VGND VPWR VPWR u_deb.cnt\[3\] sky130_fd_sc_hd__dfrtp_1
XTAP_TAPCELL_ROW_20_143 VGND VPWR sky130_fd_sc_hd__tapvpwrvgnd_1
XFILLER_10_115 VGND VGND VPWR VPWR sky130_fd_sc_hd__fill_2
X_276_ u_tick.cnt\[12\] _109_ _089_ VGND VGND VPWR VPWR _110_ sky130_fd_sc_hd__o21ai_1
X_345_ net7 net8 VGND VGND VPWR VPWR _163_ sky130_fd_sc_hd__or2_1
XFILLER_5_141 VPWR VGND VPWR VGND sky130_ef_sc_hd__decap_12
X_414_ clknet_3_3__leaf_clk _031_ net4 VGND VGND VPWR VPWR u_fsm.aux\[2\] sky130_fd_sc_hd__dfrtp_1
XTAP_TAPCELL_ROW_11_110 VGND VPWR sky130_fd_sc_hd__tapvpwrvgnd_1
XPHY_EDGE_ROW_21_Right_21 VGND VGND VPWR VPWR sky130_fd_sc_hd__decap_3
XPHY_EDGE_ROW_12_Right_12 VGND VGND VPWR VPWR sky130_fd_sc_hd__decap_3
XPHY_EDGE_ROW_30_Right_30 VGND VGND VPWR VPWR sky130_fd_sc_hd__decap_3
XFILLER_23_76 VGND VGND VPWR VPWR sky130_fd_sc_hd__fill_1
X_259_ u_tick.cnt\[5\] u_tick.cnt\[4\] u_tick.cnt\[6\] _094_ VGND VGND VPWR VPWR _099_
+ sky130_fd_sc_hd__and4_1
X_328_ net37 _146_ VGND VGND VPWR VPWR _031_ sky130_fd_sc_hd__and2_1
XFILLER_18_76 VGND VGND VPWR VPWR sky130_fd_sc_hd__decap_8
Xhold31 u_tick.cnt\[13\] VGND VGND VPWR VPWR net58 sky130_fd_sc_hd__dlygate4sd3_1
Xhold20 net13 VGND VGND VPWR VPWR net47 sky130_fd_sc_hd__dlygate4sd3_1
XFILLER_25_198 VGND VGND VPWR VPWR sky130_fd_sc_hd__fill_1
XPHY_EDGE_ROW_6_Right_6 VGND VGND VPWR VPWR sky130_fd_sc_hd__decap_3
XFILLER_31_102 VGND VGND VPWR VPWR sky130_fd_sc_hd__fill_1
Xoutput21 net21 VGND VGND VPWR VPWR good_cnt[5] sky130_fd_sc_hd__buf_1
Xoutput10 net10 VGND VGND VPWR VPWR bad_cnt[3] sky130_fd_sc_hd__buf_1
Xoutput8 net8 VGND VGND VPWR VPWR bad_cnt[1] sky130_fd_sc_hd__buf_1
XTAP_TAPCELL_ROW_32_185 VGND VPWR sky130_fd_sc_hd__tapvpwrvgnd_1
X_292_ u_fsm.mode_r\[1\] u_fsm.mode_r\[0\] VGND VGND VPWR VPWR _122_ sky130_fd_sc_hd__xnor2_2
X_361_ net17 net16 net18 net19 VGND VGND VPWR VPWR _172_ sky130_fd_sc_hd__and4_1
XTAP_TAPCELL_ROW_23_152 VGND VPWR sky130_fd_sc_hd__tapvpwrvgnd_1
X_430_ clknet_3_2__leaf_clk _003_ net4 VGND VGND VPWR VPWR u_deb.cnt\[2\] sky130_fd_sc_hd__dfrtp_1
XTAP_TAPCELL_ROW_20_144 VGND VPWR sky130_fd_sc_hd__tapvpwrvgnd_1
XFILLER_10_138 VGND VGND VPWR VPWR sky130_fd_sc_hd__fill_2
X_275_ _088_ _108_ _109_ VGND VGND VPWR VPWR _015_ sky130_fd_sc_hd__nor3_1
XFILLER_5_153 VGND VGND VPWR VPWR sky130_fd_sc_hd__fill_2
XFILLER_5_164 VGND VGND VPWR VPWR sky130_fd_sc_hd__decap_4
X_344_ _162_ _161_ net7 VGND VGND VPWR VPWR _035_ sky130_fd_sc_hd__mux2_1
X_413_ clknet_3_0__leaf_clk _030_ net4 VGND VGND VPWR VPWR u_fsm.aux\[1\] sky130_fd_sc_hd__dfrtp_1
XTAP_TAPCELL_ROW_11_111 VGND VPWR sky130_fd_sc_hd__tapvpwrvgnd_1
XFILLER_0_15 VPWR VGND VPWR VGND sky130_ef_sc_hd__decap_12
XFILLER_3_3 VPWR VGND VPWR VGND sky130_ef_sc_hd__decap_12
XFILLER_9_35 VGND VGND VPWR VPWR sky130_fd_sc_hd__fill_1
X_258_ _088_ _097_ _098_ VGND VGND VPWR VPWR _023_ sky130_fd_sc_hd__nor3_1
X_327_ net32 _146_ VGND VGND VPWR VPWR _030_ sky130_fd_sc_hd__and2_1
XFILLER_9_57 VPWR VGND VPWR VGND sky130_ef_sc_hd__decap_12
XFILLER_29_65 VPWR VGND VPWR VGND sky130_ef_sc_hd__decap_12
XFILLER_29_54 VGND VGND VPWR VPWR sky130_fd_sc_hd__fill_2
XFILLER_28_141 VGND VGND VPWR VPWR sky130_fd_sc_hd__decap_3
Xhold21 net19 VGND VGND VPWR VPWR net48 sky130_fd_sc_hd__dlygate4sd3_1
Xhold32 net20 VGND VGND VPWR VPWR net59 sky130_fd_sc_hd__dlygate4sd3_1
Xhold10 u_fsm.aux\[2\] VGND VGND VPWR VPWR net37 sky130_fd_sc_hd__dlygate4sd3_1
XFILLER_31_55 VGND VGND VPWR VPWR sky130_fd_sc_hd__fill_1
XFILLER_25_133 VGND VGND VPWR VPWR sky130_fd_sc_hd__fill_2
Xoutput22 net22 VGND VGND VPWR VPWR good_cnt[6] sky130_fd_sc_hd__buf_1
Xoutput9 net9 VGND VGND VPWR VPWR bad_cnt[2] sky130_fd_sc_hd__buf_1
Xoutput11 net11 VGND VGND VPWR VPWR bad_cnt[4] sky130_fd_sc_hd__buf_1
XFILLER_31_169 VGND VGND VPWR VPWR sky130_fd_sc_hd__decap_8
XTAP_TAPCELL_ROW_32_186 VGND VPWR sky130_fd_sc_hd__tapvpwrvgnd_1
X_291_ u_fsm.secs\[0\] _118_ _120_ u_fsm.secs\[2\] u_fsm.secs\[1\] VGND VGND VPWR
+ VPWR _121_ sky130_fd_sc_hd__a221o_1
X_360_ net17 net16 net18 VGND VGND VPWR VPWR _171_ sky130_fd_sc_hd__nand3_1
XTAP_TAPCELL_ROW_23_153 VGND VPWR sky130_fd_sc_hd__tapvpwrvgnd_1
XFILLER_13_169 VGND VGND VPWR VPWR sky130_fd_sc_hd__decap_8
XTAP_TAPCELL_ROW_14_120 VGND VPWR sky130_fd_sc_hd__tapvpwrvgnd_1
XFILLER_3_15 VGND VGND VPWR VPWR sky130_fd_sc_hd__decap_6
XPHY_EDGE_ROW_19_Left_53 VGND VGND VPWR VPWR sky130_fd_sc_hd__decap_3
X_274_ u_tick.cnt\[11\] u_tick.cnt\[10\] _105_ VGND VGND VPWR VPWR _109_ sky130_fd_sc_hd__and3_2
X_412_ clknet_3_1__leaf_clk _029_ net4 VGND VGND VPWR VPWR u_fsm.aux\[0\] sky130_fd_sc_hd__dfrtp_1
XFILLER_5_187 VPWR VGND VPWR VGND sky130_ef_sc_hd__decap_12
X_343_ net1 bad_inc _160_ VGND VGND VPWR VPWR _162_ sky130_fd_sc_hd__and3b_2
XTAP_TAPCELL_ROW_11_112 VGND VPWR sky130_fd_sc_hd__tapvpwrvgnd_1
XFILLER_4_91 VPWR VGND VPWR VGND sky130_ef_sc_hd__decap_12
XFILLER_0_27 VGND VGND VPWR VPWR sky130_fd_sc_hd__fill_1
XPHY_EDGE_ROW_4_Left_38 VGND VGND VPWR VPWR sky130_fd_sc_hd__decap_3
XFILLER_29_3 VPWR VGND VPWR VGND sky130_ef_sc_hd__decap_12
X_257_ u_tick.cnt\[5\] u_tick.cnt\[4\] _094_ VGND VGND VPWR VPWR _098_ sky130_fd_sc_hd__and3_1
X_326_ _150_ net55 _146_ VGND VGND VPWR VPWR _029_ sky130_fd_sc_hd__mux2_1
XTAP_TAPCELL_ROW_0_70 VGND VPWR sky130_fd_sc_hd__tapvpwrvgnd_1
XFILLER_9_69 VGND VGND VPWR VPWR sky130_fd_sc_hd__decap_4
X_309_ _134_ _135_ sensor_clean VGND VGND VPWR VPWR _012_ sky130_fd_sc_hd__and3b_1
XFILLER_29_109 VGND VGND VPWR VPWR sky130_fd_sc_hd__decap_3
XFILLER_29_77 VPWR VGND VPWR VGND sky130_ef_sc_hd__decap_12
XFILLER_29_33 VGND VGND VPWR VPWR sky130_fd_sc_hd__fill_1
XFILLER_28_197 VGND VGND VPWR VPWR sky130_fd_sc_hd__fill_2
Xhold11 net22 VGND VGND VPWR VPWR net38 sky130_fd_sc_hd__dlygate4sd3_1
Xhold33 u_tick.cnt\[14\] VGND VGND VPWR VPWR net60 sky130_fd_sc_hd__dlygate4sd3_1
Xhold22 net10 VGND VGND VPWR VPWR net49 sky130_fd_sc_hd__dlygate4sd3_1
XFILLER_6_15 VPWR VGND VPWR VGND sky130_ef_sc_hd__decap_12
XPHY_EDGE_ROW_7_Left_41 VGND VGND VPWR VPWR sky130_fd_sc_hd__decap_3
XPHY_EDGE_ROW_33_Left_67 VGND VGND VPWR VPWR sky130_fd_sc_hd__decap_3
XFILLER_15_57 VGND VGND VPWR VPWR sky130_fd_sc_hd__decap_3
Xoutput23 net23 VGND VGND VPWR VPWR good_cnt[7] sky130_fd_sc_hd__buf_1
Xoutput12 net12 VGND VGND VPWR VPWR bad_cnt[5] sky130_fd_sc_hd__buf_1
XTAP_TAPCELL_ROW_26_162 VGND VPWR sky130_fd_sc_hd__tapvpwrvgnd_1
X_290_ u_fsm.mode_r\[1\] u_fsm.mode_r\[0\] VGND VGND VPWR VPWR _120_ sky130_fd_sc_hd__and2b_1
XTAP_TAPCELL_ROW_23_154 VGND VPWR sky130_fd_sc_hd__tapvpwrvgnd_1
XFILLER_21_181 VGND VGND VPWR VPWR sky130_fd_sc_hd__fill_1
XTAP_TAPCELL_ROW_14_121 VGND VPWR sky130_fd_sc_hd__tapvpwrvgnd_1
XFILLER_8_141 VGND VGND VPWR VPWR sky130_fd_sc_hd__decap_6
X_411_ _089_ _202_ VGND VGND VPWR VPWR _062_ sky130_fd_sc_hd__and2_1
X_273_ u_tick.cnt\[10\] _105_ net54 VGND VGND VPWR VPWR _108_ sky130_fd_sc_hd__a21oi_1
XFILLER_5_111 VGND VGND VPWR VPWR sky130_fd_sc_hd__fill_1
X_342_ bad_inc _160_ net1 VGND VGND VPWR VPWR _161_ sky130_fd_sc_hd__a21oi_4
XPHY_EDGE_ROW_20_Left_54 VGND VGND VPWR VPWR sky130_fd_sc_hd__decap_3
XFILLER_23_57 VGND VGND VPWR VPWR sky130_fd_sc_hd__decap_4
X_256_ u_tick.cnt\[4\] _094_ net63 VGND VGND VPWR VPWR _097_ sky130_fd_sc_hd__a21oi_1
X_325_ u_fsm.aux\[0\] _149_ VGND VGND VPWR VPWR _150_ sky130_fd_sc_hd__nor2_1
XTAP_TAPCELL_ROW_0_71 VGND VPWR sky130_fd_sc_hd__tapvpwrvgnd_1
XFILLER_9_15 VPWR VGND VPWR VGND sky130_ef_sc_hd__decap_12
Xclkload0 clknet_3_0__leaf_clk VGND VGND VPWR VPWR clkload0/Y sky130_fd_sc_hd__bufinv_16
X_308_ u_fsm.state\[1\] _063_ u_fsm.state\[2\] VGND VGND VPWR VPWR _135_ sky130_fd_sc_hd__nor3_2
X_239_ u_deb.cnt\[10\] _084_ VGND VGND VPWR VPWR _086_ sky130_fd_sc_hd__nand2_1
Xhold34 net17 VGND VGND VPWR VPWR net61 sky130_fd_sc_hd__dlygate4sd3_1
XFILLER_29_89 VPWR VGND VPWR VGND sky130_ef_sc_hd__decap_12
Xhold23 u_tick.cnt\[8\] VGND VGND VPWR VPWR net50 sky130_fd_sc_hd__dlygate4sd3_1
XFILLER_28_121 VPWR VGND VPWR VGND sky130_ef_sc_hd__decap_12
XFILLER_20_69 VGND VGND VPWR VPWR sky130_fd_sc_hd__fill_1
Xhold12 u_deb.cnt\[8\] VGND VGND VPWR VPWR net39 sky130_fd_sc_hd__dlygate4sd3_1
XFILLER_19_198 VGND VGND VPWR VPWR sky130_fd_sc_hd__fill_1
XFILLER_19_154 VGND VGND VPWR VPWR sky130_fd_sc_hd__fill_2
XFILLER_6_27 VGND VGND VPWR VPWR sky130_fd_sc_hd__fill_1
XTAP_TAPCELL_ROW_6_92 VGND VPWR sky130_fd_sc_hd__tapvpwrvgnd_1
XFILLER_31_57 VGND VGND VPWR VPWR sky130_fd_sc_hd__decap_8
Xoutput24 net24 VGND VGND VPWR VPWR led_done sky130_fd_sc_hd__buf_1
Xoutput13 net13 VGND VGND VPWR VPWR bad_cnt[6] sky130_fd_sc_hd__buf_1
XPHY_EDGE_ROW_28_Right_28 VGND VGND VPWR VPWR sky130_fd_sc_hd__decap_3
XTAP_TAPCELL_ROW_26_163 VGND VPWR sky130_fd_sc_hd__tapvpwrvgnd_1
XPHY_EDGE_ROW_19_Right_19 VGND VGND VPWR VPWR sky130_fd_sc_hd__decap_3
Xclkbuf_3_1__f_clk clknet_0_clk VGND VGND VPWR VPWR clknet_3_1__leaf_clk sky130_fd_sc_hd__clkbuf_16
XFILLER_30_182 VGND VGND VPWR VPWR sky130_fd_sc_hd__decap_8
XFILLER_30_171 VGND VGND VPWR VPWR sky130_fd_sc_hd__decap_6
XFILLER_13_149 VPWR VGND VPWR VGND sky130_ef_sc_hd__decap_12
XFILLER_13_105 VGND VGND VPWR VPWR sky130_fd_sc_hd__decap_6
XFILLER_16_90 VGND VGND VPWR VPWR sky130_fd_sc_hd__decap_3
XTAP_TAPCELL_ROW_14_122 VGND VPWR sky130_fd_sc_hd__tapvpwrvgnd_1
XFILLER_12_171 VGND VGND VPWR VPWR sky130_fd_sc_hd__fill_2
XTAP_TAPCELL_ROW_3_82 VGND VPWR sky130_fd_sc_hd__tapvpwrvgnd_1
XFILLER_8_175 VGND VGND VPWR VPWR sky130_fd_sc_hd__fill_1
XFILLER_8_197 VGND VGND VPWR VPWR sky130_fd_sc_hd__fill_2
X_410_ u_fsm.secs\[4\] _131_ _194_ _196_ u_fsm.secs\[5\] VGND VGND VPWR VPWR _202_
+ sky130_fd_sc_hd__a41o_1
X_272_ net53 _105_ _107_ VGND VGND VPWR VPWR _014_ sky130_fd_sc_hd__o21a_1
X_341_ net14 _158_ VGND VGND VPWR VPWR _160_ sky130_fd_sc_hd__nand2_1
XFILLER_12_15 VPWR VGND VPWR VGND sky130_ef_sc_hd__decap_12
X_255_ net56 _094_ _096_ VGND VGND VPWR VPWR _022_ sky130_fd_sc_hd__o21a_1
X_324_ sensor_clean _115_ _145_ _147_ VGND VGND VPWR VPWR _149_ sky130_fd_sc_hd__o2bb2a_1
XFILLER_0_29 VPWR VGND VPWR VGND sky130_ef_sc_hd__decap_12
XFILLER_9_27 VGND VGND VPWR VPWR sky130_fd_sc_hd__decap_8
XTAP_TAPCELL_ROW_0_72 VGND VPWR sky130_fd_sc_hd__tapvpwrvgnd_1
Xclkload1 clknet_3_1__leaf_clk VGND VGND VPWR VPWR clkload1/X sky130_fd_sc_hd__clkbuf_8
XFILLER_1_3 VPWR VGND VPWR VGND sky130_ef_sc_hd__decap_12
X_307_ _117_ _134_ VGND VGND VPWR VPWR net27 sky130_fd_sc_hd__nor2_1
X_238_ _084_ _085_ VGND VGND VPWR VPWR _010_ sky130_fd_sc_hd__nor2_1
XFILLER_28_133 VGND VGND VPWR VPWR sky130_fd_sc_hd__decap_6
Xhold13 u_tick.cnt\[6\] VGND VGND VPWR VPWR net40 sky130_fd_sc_hd__dlygate4sd3_1
Xhold24 u_tick.cnt\[12\] VGND VGND VPWR VPWR net51 sky130_fd_sc_hd__dlygate4sd3_1
XFILLER_20_59 VGND VGND VPWR VPWR sky130_fd_sc_hd__decap_3
XFILLER_20_15 VPWR VGND VPWR VGND sky130_ef_sc_hd__decap_12
Xhold35 u_tick.cnt\[2\] VGND VGND VPWR VPWR net62 sky130_fd_sc_hd__dlygate4sd3_1
XFILLER_19_177 VGND VGND VPWR VPWR sky130_fd_sc_hd__fill_1
XFILLER_19_166 VGND VGND VPWR VPWR sky130_fd_sc_hd__fill_2
XFILLER_19_133 VGND VGND VPWR VPWR sky130_fd_sc_hd__decap_4
XTAP_TAPCELL_ROW_6_93 VGND VPWR sky130_fd_sc_hd__tapvpwrvgnd_1
XFILLER_25_125 VGND VGND VPWR VPWR sky130_fd_sc_hd__decap_8
XFILLER_15_15 VPWR VGND VPWR VGND sky130_ef_sc_hd__decap_12
Xoutput25 net25 VGND VGND VPWR VPWR led_progress[0] sky130_fd_sc_hd__buf_1
XTAP_TAPCELL_ROW_26_164 VGND VPWR sky130_fd_sc_hd__tapvpwrvgnd_1
Xoutput14 net14 VGND VGND VPWR VPWR bad_cnt[7] sky130_fd_sc_hd__buf_1
XTAP_TAPCELL_ROW_17_131 VGND VPWR sky130_fd_sc_hd__tapvpwrvgnd_1
XFILLER_7_93 VPWR VGND VPWR VGND sky130_ef_sc_hd__decap_12
XTAP_TAPCELL_ROW_14_123 VGND VPWR sky130_fd_sc_hd__tapvpwrvgnd_1
XTAP_TAPCELL_ROW_3_83 VGND VPWR sky130_fd_sc_hd__tapvpwrvgnd_1
XFILLER_12_27 VGND VGND VPWR VPWR sky130_fd_sc_hd__fill_1
X_271_ u_tick.cnt\[10\] _105_ _088_ VGND VGND VPWR VPWR _107_ sky130_fd_sc_hd__a21oi_1
X_340_ _158_ VGND VGND VPWR VPWR _159_ sky130_fd_sc_hd__inv_2
XFILLER_23_15 VGND VGND VPWR VPWR sky130_fd_sc_hd__decap_6
XFILLER_4_50 VGND VGND VPWR VPWR sky130_fd_sc_hd__decap_8
X_469_ clknet_3_3__leaf_clk _011_ net4 VGND VGND VPWR VPWR bad_inc sky130_fd_sc_hd__dfrtp_1
X_254_ u_tick.cnt\[4\] _094_ _088_ VGND VGND VPWR VPWR _096_ sky130_fd_sc_hd__a21oi_1
X_323_ _147_ VGND VGND VPWR VPWR _148_ sky130_fd_sc_hd__inv_2
XFILLER_13_81 VPWR VGND VPWR VGND sky130_ef_sc_hd__decap_12
XTAP_TAPCELL_ROW_0_73 VGND VPWR sky130_fd_sc_hd__tapvpwrvgnd_1
XFILLER_18_37 VGND VGND VPWR VPWR sky130_fd_sc_hd__fill_2
XFILLER_18_15 VPWR VGND VPWR VGND sky130_ef_sc_hd__decap_12
Xclkload2 clknet_3_3__leaf_clk VGND VGND VPWR VPWR clkload2/Y sky130_fd_sc_hd__clkinvlp_4
X_306_ u_fsm.secs\[4\] _132_ _133_ VGND VGND VPWR VPWR _134_ sky130_fd_sc_hd__a21oi_1
XFILLER_27_3 VPWR VGND VPWR VGND sky130_ef_sc_hd__decap_12
X_237_ net44 _082_ _069_ VGND VGND VPWR VPWR _085_ sky130_fd_sc_hd__o21ai_1
Xhold36 u_tick.cnt\[5\] VGND VGND VPWR VPWR net63 sky130_fd_sc_hd__dlygate4sd3_1
XFILLER_20_27 VGND VGND VPWR VPWR sky130_fd_sc_hd__fill_1
Xhold25 u_deb.cnt\[7\] VGND VGND VPWR VPWR net52 sky130_fd_sc_hd__dlygate4sd3_1
Xhold14 net14 VGND VGND VPWR VPWR net41 sky130_fd_sc_hd__dlygate4sd3_1
XTAP_TAPCELL_ROW_29_173 VGND VPWR sky130_fd_sc_hd__tapvpwrvgnd_1
XFILLER_6_29 VPWR VGND VPWR VGND sky130_ef_sc_hd__decap_12
XFILLER_10_93 VGND VGND VPWR VPWR sky130_fd_sc_hd__fill_2
XFILLER_33_181 VPWR VGND VPWR VGND sky130_ef_sc_hd__decap_12
XFILLER_15_27 VGND VGND VPWR VPWR sky130_fd_sc_hd__decap_4
XTAP_TAPCELL_ROW_6_94 VGND VPWR sky130_fd_sc_hd__tapvpwrvgnd_1
Xoutput26 net26 VGND VGND VPWR VPWR led_progress[1] sky130_fd_sc_hd__buf_1
XFILLER_31_15 VPWR VGND VPWR VGND sky130_ef_sc_hd__decap_12
XTAP_TAPCELL_ROW_26_165 VGND VPWR sky130_fd_sc_hd__tapvpwrvgnd_1
XFILLER_16_126 VGND VGND VPWR VPWR sky130_fd_sc_hd__fill_1
Xoutput15 net15 VGND VGND VPWR VPWR buzzer sky130_fd_sc_hd__buf_1
XPHY_EDGE_ROW_1_Right_1 VGND VGND VPWR VPWR sky130_fd_sc_hd__decap_3
XTAP_TAPCELL_ROW_17_132 VGND VPWR sky130_fd_sc_hd__tapvpwrvgnd_1
XFILLER_11_6 VPWR VGND VPWR VGND sky130_ef_sc_hd__decap_12
XFILLER_26_15 VPWR VGND VPWR VGND sky130_ef_sc_hd__decap_12
XFILLER_21_195 VGND VGND VPWR VPWR sky130_fd_sc_hd__fill_1
XFILLER_21_162 VGND VGND VPWR VPWR sky130_fd_sc_hd__decap_6
XTAP_TAPCELL_ROW_8_100 VGND VPWR sky130_fd_sc_hd__tapvpwrvgnd_1
XTAP_TAPCELL_ROW_3_84 VGND VPWR sky130_fd_sc_hd__tapvpwrvgnd_1
X_270_ _104_ _106_ VGND VGND VPWR VPWR _027_ sky130_fd_sc_hd__and2_1
XFILLER_5_169 VPWR VGND VPWR VGND sky130_ef_sc_hd__decap_12
X_399_ u_fsm.secs\[0\] _195_ _194_ VGND VGND VPWR VPWR _057_ sky130_fd_sc_hd__mux2_1
X_468_ clknet_3_1__leaf_clk _056_ net4 VGND VGND VPWR VPWR sensor_clean sky130_fd_sc_hd__dfrtp_4
X_322_ net15 _141_ VGND VGND VPWR VPWR _147_ sky130_fd_sc_hd__nor2_1
XFILLER_2_139 VGND VGND VPWR VPWR sky130_fd_sc_hd__fill_1
Xclkbuf_3_7__f_clk clknet_0_clk VGND VGND VPWR VPWR clknet_3_7__leaf_clk sky130_fd_sc_hd__clkbuf_16
XPHY_EDGE_ROW_24_Left_58 VGND VGND VPWR VPWR sky130_fd_sc_hd__decap_3
X_253_ _089_ _093_ _095_ VGND VGND VPWR VPWR _021_ sky130_fd_sc_hd__and3_1
XFILLER_13_93 VPWR VGND VPWR VGND sky130_ef_sc_hd__decap_12
XTAP_TAPCELL_ROW_0_74 VGND VPWR sky130_fd_sc_hd__tapvpwrvgnd_1
Xclkload3 clknet_3_4__leaf_clk VGND VGND VPWR VPWR clkload3/Y sky130_fd_sc_hd__clkinv_4
XFILLER_18_27 VGND VGND VPWR VPWR sky130_fd_sc_hd__fill_1
X_305_ u_fsm.secs\[3\] u_fsm.secs\[4\] _119_ u_fsm.secs\[5\] VGND VGND VPWR VPWR _133_
+ sky130_fd_sc_hd__o31a_1
X_236_ u_deb.cnt\[9\] _082_ VGND VGND VPWR VPWR _084_ sky130_fd_sc_hd__and2_1
XFILLER_29_15 VPWR VGND VPWR VGND sky130_ef_sc_hd__decap_12
XFILLER_28_179 VGND VGND VPWR VPWR sky130_fd_sc_hd__decap_3
Xhold26 u_tick.cnt\[10\] VGND VGND VPWR VPWR net53 sky130_fd_sc_hd__dlygate4sd3_1
XFILLER_19_113 VGND VGND VPWR VPWR sky130_fd_sc_hd__decap_4
Xhold15 net23 VGND VGND VPWR VPWR net42 sky130_fd_sc_hd__dlygate4sd3_1
Xhold37 net8 VGND VGND VPWR VPWR net64 sky130_fd_sc_hd__dlygate4sd3_1
XTAP_TAPCELL_ROW_29_174 VGND VPWR sky130_fd_sc_hd__tapvpwrvgnd_1
XPHY_EDGE_ROW_27_Left_61 VGND VGND VPWR VPWR sky130_fd_sc_hd__decap_3
XFILLER_19_146 VGND VGND VPWR VPWR sky130_fd_sc_hd__decap_8
XFILLER_19_124 VGND VGND VPWR VPWR sky130_fd_sc_hd__fill_2
X_219_ u_deb.cnt\[3\] u_deb.cnt\[2\] u_deb.cnt\[1\] u_deb.cnt\[0\] VGND VGND VPWR
+ VPWR _073_ sky130_fd_sc_hd__and4_1
XTAP_TAPCELL_ROW_6_95 VGND VPWR sky130_fd_sc_hd__tapvpwrvgnd_1
XPHY_EDGE_ROW_11_Left_45 VGND VGND VPWR VPWR sky130_fd_sc_hd__decap_3
XFILLER_33_193 VGND VGND VPWR VPWR sky130_fd_sc_hd__decap_3
Xoutput27 net27 VGND VGND VPWR VPWR led_progress[2] sky130_fd_sc_hd__buf_1
XFILLER_31_27 VPWR VGND VPWR VGND sky130_ef_sc_hd__decap_12
Xoutput16 net16 VGND VGND VPWR VPWR good_cnt[0] sky130_fd_sc_hd__buf_1
XFILLER_16_138 VGND VGND VPWR VPWR sky130_fd_sc_hd__fill_2
XFILLER_15_39 VGND VGND VPWR VPWR sky130_fd_sc_hd__fill_1
XFILLER_22_119 VGND VGND VPWR VPWR sky130_fd_sc_hd__decap_3
XFILLER_21_82 VPWR VGND VPWR VGND sky130_ef_sc_hd__decap_12
XTAP_TAPCELL_ROW_17_133 VGND VPWR sky130_fd_sc_hd__tapvpwrvgnd_1
Xclkbuf_0_clk clk VGND VGND VPWR VPWR clknet_0_clk sky130_fd_sc_hd__clkbuf_16
XFILLER_26_27 VGND VGND VPWR VPWR sky130_fd_sc_hd__fill_1
XPHY_EDGE_ROW_24_Right_24 VGND VGND VPWR VPWR sky130_fd_sc_hd__decap_3
XPHY_EDGE_ROW_15_Right_15 VGND VGND VPWR VPWR sky130_fd_sc_hd__decap_3
XFILLER_7_40 VGND VGND VPWR VPWR sky130_fd_sc_hd__fill_1
XPHY_EDGE_ROW_33_Right_33 VGND VGND VPWR VPWR sky130_fd_sc_hd__decap_3
XTAP_TAPCELL_ROW_31_180 VGND VPWR sky130_fd_sc_hd__tapvpwrvgnd_1
XFILLER_12_163 VGND VGND VPWR VPWR sky130_fd_sc_hd__decap_8
XFILLER_12_141 VGND VGND VPWR VPWR sky130_fd_sc_hd__fill_2
XTAP_TAPCELL_ROW_8_101 VGND VPWR sky130_fd_sc_hd__tapvpwrvgnd_1
XFILLER_8_167 VGND VGND VPWR VPWR sky130_fd_sc_hd__decap_3
XFILLER_12_29 VPWR VGND VPWR VGND sky130_ef_sc_hd__decap_12
X_467_ clknet_3_5__leaf_clk _055_ net4 VGND VGND VPWR VPWR u_fsm.mode_r\[1\] sky130_fd_sc_hd__dfrtp_2
X_398_ _063_ u_fsm.secs\[0\] VGND VGND VPWR VPWR _195_ sky130_fd_sc_hd__nor2_1
XFILLER_4_170 VGND VGND VPWR VPWR sky130_fd_sc_hd__decap_3
X_252_ _094_ VGND VGND VPWR VPWR _095_ sky130_fd_sc_hd__inv_2
X_321_ net15 _145_ _144_ _142_ VGND VGND VPWR VPWR _146_ sky130_fd_sc_hd__a211o_1
X_304_ u_fsm.secs\[1\] _119_ _131_ _125_ _122_ VGND VGND VPWR VPWR _132_ sky130_fd_sc_hd__a32o_1
Xclkload4 clknet_3_5__leaf_clk VGND VGND VPWR VPWR clkload4/Y sky130_fd_sc_hd__bufinv_16
XFILLER_24_93 VPWR VGND VPWR VGND sky130_ef_sc_hd__decap_12
X_235_ _082_ _083_ VGND VGND VPWR VPWR _009_ sky130_fd_sc_hd__nor2_1
XFILLER_20_29 VGND VGND VPWR VPWR sky130_fd_sc_hd__decap_4
XFILLER_1_86 VGND VGND VPWR VPWR sky130_fd_sc_hd__decap_6
XFILLER_29_27 VGND VGND VPWR VPWR sky130_fd_sc_hd__decap_6
Xhold27 u_tick.cnt\[11\] VGND VGND VPWR VPWR net54 sky130_fd_sc_hd__dlygate4sd3_1
Xhold16 u_deb.cnt\[6\] VGND VGND VPWR VPWR net43 sky130_fd_sc_hd__dlygate4sd3_1
XFILLER_32_3 VPWR VGND VPWR VGND sky130_ef_sc_hd__decap_12
XTAP_TAPCELL_ROW_29_175 VGND VPWR sky130_fd_sc_hd__tapvpwrvgnd_1
XFILLER_19_169 VGND VGND VPWR VPWR sky130_fd_sc_hd__decap_8
XFILLER_19_82 VGND VGND VPWR VPWR sky130_fd_sc_hd__fill_2
X_218_ _071_ _072_ _069_ VGND VGND VPWR VPWR _003_ sky130_fd_sc_hd__and3b_1
XFILLER_31_39 VPWR VGND VPWR VGND sky130_ef_sc_hd__decap_12
Xoutput17 net17 VGND VGND VPWR VPWR good_cnt[1] sky130_fd_sc_hd__buf_1
XFILLER_25_139 VGND VGND VPWR VPWR sky130_fd_sc_hd__fill_2
XFILLER_21_94 VPWR VGND VPWR VGND sky130_ef_sc_hd__decap_12
XFILLER_21_61 VGND VGND VPWR VPWR sky130_fd_sc_hd__fill_1
XFILLER_30_197 VGND VGND VPWR VPWR sky130_fd_sc_hd__fill_2
XFILLER_7_52 VGND VGND VPWR VPWR sky130_fd_sc_hd__decap_4
XTAP_TAPCELL_ROW_31_181 VGND VPWR sky130_fd_sc_hd__tapvpwrvgnd_1
XFILLER_16_83 VGND VGND VPWR VPWR sky130_fd_sc_hd__fill_1
XTAP_TAPCELL_ROW_8_102 VGND VPWR sky130_fd_sc_hd__tapvpwrvgnd_1
XFILLER_12_197 VGND VGND VPWR VPWR sky130_fd_sc_hd__fill_2
XFILLER_5_105 VGND VGND VPWR VPWR sky130_fd_sc_hd__decap_6
X_466_ clknet_3_5__leaf_clk _054_ net4 VGND VGND VPWR VPWR u_fsm.mode_r\[0\] sky130_fd_sc_hd__dfrtp_1
X_397_ _063_ tick _117_ _134_ _191_ VGND VGND VPWR VPWR _194_ sky130_fd_sc_hd__o221a_2
XFILLER_2_119 VPWR VGND VPWR VGND sky130_ef_sc_hd__decap_12
X_251_ u_tick.cnt\[1\] u_tick.cnt\[0\] u_tick.cnt\[3\] u_tick.cnt\[2\] VGND VGND VPWR
+ VPWR _094_ sky130_fd_sc_hd__and4_2
XFILLER_13_51 VGND VGND VPWR VPWR sky130_fd_sc_hd__decap_4
XFILLER_13_40 VGND VGND VPWR VPWR sky130_fd_sc_hd__decap_6
X_320_ _137_ _139_ tick VGND VGND VPWR VPWR _145_ sky130_fd_sc_hd__o21ai_1
X_449_ clknet_3_5__leaf_clk _027_ net4 VGND VGND VPWR VPWR u_tick.cnt\[9\] sky130_fd_sc_hd__dfrtp_1
XFILLER_18_29 VGND VGND VPWR VPWR sky130_fd_sc_hd__decap_8
Xclkload5 clknet_3_6__leaf_clk VGND VGND VPWR VPWR clkload5/Y sky130_fd_sc_hd__clkinv_4
X_303_ u_fsm.secs\[3\] u_fsm.secs\[2\] VGND VGND VPWR VPWR _131_ sky130_fd_sc_hd__and2_1
XFILLER_1_65 VGND VGND VPWR VPWR sky130_fd_sc_hd__fill_1
X_234_ net39 _080_ _069_ VGND VGND VPWR VPWR _083_ sky130_fd_sc_hd__o21ai_1
Xhold28 u_fsm.aux\[0\] VGND VGND VPWR VPWR net55 sky130_fd_sc_hd__dlygate4sd3_1
Xhold17 u_deb.cnt\[9\] VGND VGND VPWR VPWR net44 sky130_fd_sc_hd__dlygate4sd3_1
XFILLER_27_181 VGND VGND VPWR VPWR sky130_fd_sc_hd__decap_3
XFILLER_19_50 VGND VGND VPWR VPWR sky130_fd_sc_hd__decap_6
XFILLER_19_61 VGND VGND VPWR VPWR sky130_fd_sc_hd__fill_1
X_217_ u_deb.cnt\[1\] u_deb.cnt\[0\] u_deb.cnt\[2\] VGND VGND VPWR VPWR _072_ sky130_fd_sc_hd__a21o_1
Xoutput18 net18 VGND VGND VPWR VPWR good_cnt[2] sky130_fd_sc_hd__buf_1
XFILLER_25_3 VPWR VGND VPWR VGND sky130_ef_sc_hd__decap_12
XFILLER_16_118 VGND VGND VPWR VPWR sky130_fd_sc_hd__decap_8
XTAP_TAPCELL_ROW_31_182 VGND VPWR sky130_fd_sc_hd__tapvpwrvgnd_1
XFILLER_26_29 VGND VGND VPWR VPWR sky130_fd_sc_hd__fill_1
XPHY_EDGE_ROW_5_Right_5 VGND VGND VPWR VPWR sky130_fd_sc_hd__decap_3
XFILLER_32_94 VPWR VGND VPWR VGND sky130_ef_sc_hd__decap_12
XFILLER_32_61 VGND VGND VPWR VPWR sky130_fd_sc_hd__fill_2
XFILLER_8_136 VGND VGND VPWR VPWR sky130_fd_sc_hd__decap_4
X_465_ clknet_3_3__leaf_clk _053_ net4 VGND VGND VPWR VPWR u_fsm.state\[2\] sky130_fd_sc_hd__dfrtp_4
X_396_ sensor_sync sensor_clean _086_ VGND VGND VPWR VPWR _056_ sky130_fd_sc_hd__mux2_1
X_250_ u_tick.cnt\[1\] u_tick.cnt\[0\] u_tick.cnt\[2\] u_tick.cnt\[3\] VGND VGND VPWR
+ VPWR _093_ sky130_fd_sc_hd__a31o_1
X_448_ clknet_3_5__leaf_clk _026_ net4 VGND VGND VPWR VPWR u_tick.cnt\[8\] sky130_fd_sc_hd__dfrtp_1
X_379_ _174_ _181_ _185_ _180_ net59 VGND VGND VPWR VPWR _047_ sky130_fd_sc_hd__a32o_1
XFILLER_1_197 VGND VGND VPWR VPWR sky130_fd_sc_hd__fill_2
Xclkload6 clknet_3_7__leaf_clk VGND VGND VPWR VPWR clkload6/Y sky130_fd_sc_hd__bufinv_16
X_302_ _129_ _130_ _116_ VGND VGND VPWR VPWR net26 sky130_fd_sc_hd__o21a_1
X_233_ u_deb.cnt\[7\] u_deb.cnt\[8\] _078_ VGND VGND VPWR VPWR _082_ sky130_fd_sc_hd__and3_1
Xhold18 net21 VGND VGND VPWR VPWR net45 sky130_fd_sc_hd__dlygate4sd3_1
Xhold29 u_tick.cnt\[4\] VGND VGND VPWR VPWR net56 sky130_fd_sc_hd__dlygate4sd3_1
XFILLER_33_141 VPWR VGND VPWR VGND sky130_ef_sc_hd__decap_12
XFILLER_25_108 VGND VGND VPWR VPWR sky130_fd_sc_hd__decap_4
XFILLER_18_3 VPWR VGND VPWR VGND sky130_ef_sc_hd__decap_12
X_216_ u_deb.cnt\[2\] u_deb.cnt\[1\] u_deb.cnt\[0\] VGND VGND VPWR VPWR _071_ sky130_fd_sc_hd__and3_1
Xoutput19 net19 VGND VGND VPWR VPWR good_cnt[3] sky130_fd_sc_hd__buf_1
XFILLER_24_185 VGND VGND VPWR VPWR sky130_fd_sc_hd__fill_1
XFILLER_24_141 VPWR VGND VPWR VGND sky130_ef_sc_hd__decap_12
XPHY_EDGE_ROW_15_Left_49 VGND VGND VPWR VPWR sky130_fd_sc_hd__decap_3
XFILLER_21_111 VGND VGND VPWR VPWR sky130_fd_sc_hd__fill_1
XTAP_TAPCELL_ROW_22_150 VGND VPWR sky130_fd_sc_hd__tapvpwrvgnd_1
XPHY_EDGE_ROW_20_Right_20 VGND VGND VPWR VPWR sky130_fd_sc_hd__decap_3
XFILLER_16_96 VGND VGND VPWR VPWR sky130_fd_sc_hd__fill_2
XPHY_EDGE_ROW_11_Right_11 VGND VGND VPWR VPWR sky130_fd_sc_hd__decap_3
X_464_ clknet_3_6__leaf_clk _052_ net4 VGND VGND VPWR VPWR u_fsm.state\[1\] sky130_fd_sc_hd__dfrtp_2
X_395_ net3 u_fsm.mode_r\[1\] _193_ VGND VGND VPWR VPWR _055_ sky130_fd_sc_hd__mux2_1
Xclkbuf_3_2__f_clk clknet_0_clk VGND VGND VPWR VPWR clknet_3_2__leaf_clk sky130_fd_sc_hd__clkbuf_16
XPHY_EDGE_ROW_18_Left_52 VGND VGND VPWR VPWR sky130_fd_sc_hd__decap_3
X_447_ clknet_3_5__leaf_clk _025_ net4 VGND VGND VPWR VPWR u_tick.cnt\[7\] sky130_fd_sc_hd__dfrtp_1
X_378_ net20 _172_ VGND VGND VPWR VPWR _185_ sky130_fd_sc_hd__or2_1
XFILLER_1_165 VGND VGND VPWR VPWR sky130_fd_sc_hd__decap_3
XPHY_EDGE_ROW_3_Left_37 VGND VGND VPWR VPWR sky130_fd_sc_hd__decap_3
X_301_ u_fsm.secs\[4\] _122_ u_fsm.secs\[5\] VGND VGND VPWR VPWR _130_ sky130_fd_sc_hd__a21o_1
X_232_ _080_ _081_ VGND VGND VPWR VPWR _008_ sky130_fd_sc_hd__nor2_1
XFILLER_28_139 VGND VGND VPWR VPWR sky130_fd_sc_hd__fill_1
Xhold19 net12 VGND VGND VPWR VPWR net46 sky130_fd_sc_hd__dlygate4sd3_1
XFILLER_33_197 VGND VGND VPWR VPWR sky130_fd_sc_hd__fill_2
XFILLER_33_153 VPWR VGND VPWR VGND sky130_ef_sc_hd__decap_12
X_215_ net35 u_deb.cnt\[0\] _070_ VGND VGND VPWR VPWR _002_ sky130_fd_sc_hd__a21oi_1
XFILLER_24_197 VGND VGND VPWR VPWR sky130_fd_sc_hd__fill_2
XFILLER_24_153 VPWR VGND VPWR VGND sky130_ef_sc_hd__decap_12
XPHY_EDGE_ROW_6_Left_40 VGND VGND VPWR VPWR sky130_fd_sc_hd__decap_3
XFILLER_30_3 VPWR VGND VPWR VGND sky130_ef_sc_hd__decap_12
XFILLER_32_85 VGND VGND VPWR VPWR sky130_fd_sc_hd__decap_3
XFILLER_32_41 VPWR VGND VPWR VGND sky130_ef_sc_hd__decap_12
XPHY_EDGE_ROW_32_Left_66 VGND VGND VPWR VPWR sky130_fd_sc_hd__decap_3
XTAP_TAPCELL_ROW_22_151 VGND VPWR sky130_fd_sc_hd__tapvpwrvgnd_1
XFILLER_16_53 VPWR VGND VPWR VGND sky130_ef_sc_hd__decap_12
XFILLER_16_42 VGND VGND VPWR VPWR sky130_fd_sc_hd__decap_4
XFILLER_12_134 VGND VGND VPWR VPWR sky130_fd_sc_hd__decap_6
XFILLER_12_112 VGND VGND VPWR VPWR sky130_fd_sc_hd__decap_8
X_394_ net2 u_fsm.mode_r\[0\] _193_ VGND VGND VPWR VPWR _054_ sky130_fd_sc_hd__mux2_1
XFILLER_27_85 VGND VGND VPWR VPWR sky130_fd_sc_hd__fill_1
X_463_ clknet_3_6__leaf_clk _051_ net4 VGND VGND VPWR VPWR u_fsm.state\[0\] sky130_fd_sc_hd__dfrtp_2
XFILLER_4_78 VGND VGND VPWR VPWR sky130_fd_sc_hd__decap_6
X_377_ _173_ _181_ _184_ _180_ net48 VGND VGND VPWR VPWR _046_ sky130_fd_sc_hd__a32o_1
X_446_ clknet_3_5__leaf_clk _024_ net4 VGND VGND VPWR VPWR u_tick.cnt\[6\] sky130_fd_sc_hd__dfrtp_1
XTAP_TAPCELL_ROW_0_68 VGND VPWR sky130_fd_sc_hd__tapvpwrvgnd_1
XFILLER_8_3 VPWR VGND VPWR VGND sky130_ef_sc_hd__decap_12
X_300_ u_fsm.secs\[3\] _120_ _128_ u_fsm.secs\[4\] _126_ VGND VGND VPWR VPWR _129_
+ sky130_fd_sc_hd__o221a_1
X_231_ net52 _078_ _069_ VGND VGND VPWR VPWR _081_ sky130_fd_sc_hd__o21ai_1
X_429_ clknet_3_2__leaf_clk net36 net4 VGND VGND VPWR VPWR u_deb.cnt\[1\] sky130_fd_sc_hd__dfrtp_1
XFILLER_1_57 VGND VGND VPWR VPWR sky130_fd_sc_hd__decap_8
XFILLER_1_35 VGND VGND VPWR VPWR sky130_fd_sc_hd__fill_1
Xinput1 clear_log VGND VGND VPWR VPWR net1 sky130_fd_sc_hd__buf_2
X_214_ u_deb.cnt\[1\] u_deb.cnt\[0\] _069_ VGND VGND VPWR VPWR _070_ sky130_fd_sc_hd__o21ai_1
XFILLER_33_165 VGND VGND VPWR VPWR sky130_fd_sc_hd__decap_3
XFILLER_24_121 VGND VGND VPWR VPWR sky130_fd_sc_hd__fill_1
XFILLER_18_173 VGND VGND VPWR VPWR sky130_fd_sc_hd__decap_8
XTAP_TAPCELL_ROW_25_160 VGND VPWR sky130_fd_sc_hd__tapvpwrvgnd_1
XFILLER_24_165 VPWR VGND VPWR VGND sky130_ef_sc_hd__decap_12
XFILLER_21_54 VGND VGND VPWR VPWR sky130_fd_sc_hd__fill_2
XFILLER_15_121 VGND VGND VPWR VPWR sky130_fd_sc_hd__decap_3
XFILLER_23_3 VPWR VGND VPWR VGND sky130_ef_sc_hd__decap_12
XFILLER_21_113 VGND VGND VPWR VPWR sky130_fd_sc_hd__decap_6
XFILLER_32_53 VGND VGND VPWR VPWR sky130_fd_sc_hd__decap_8
XFILLER_16_65 VPWR VGND VPWR VGND sky130_ef_sc_hd__decap_12
XFILLER_8_117 VGND VGND VPWR VPWR sky130_fd_sc_hd__fill_1
XFILLER_7_150 VPWR VGND VPWR VGND sky130_ef_sc_hd__decap_12
XPHY_EDGE_ROW_9_Right_9 VGND VGND VPWR VPWR sky130_fd_sc_hd__decap_3
X_393_ sensor_clean _088_ VGND VGND VPWR VPWR _193_ sky130_fd_sc_hd__nand2_1
X_462_ clknet_3_3__leaf_clk _050_ net4 VGND VGND VPWR VPWR net23 sky130_fd_sc_hd__dfrtp_1
XFILLER_4_131 VGND VGND VPWR VPWR sky130_fd_sc_hd__decap_8
XFILLER_4_197 VGND VGND VPWR VPWR sky130_fd_sc_hd__fill_2
XFILLER_13_55 VGND VGND VPWR VPWR sky130_fd_sc_hd__fill_1
XTAP_TAPCELL_ROW_0_69 VGND VPWR sky130_fd_sc_hd__tapvpwrvgnd_1
X_376_ net17 net16 net18 net19 VGND VGND VPWR VPWR _184_ sky130_fd_sc_hd__a31o_1
X_445_ clknet_3_4__leaf_clk _023_ net4 VGND VGND VPWR VPWR u_tick.cnt\[5\] sky130_fd_sc_hd__dfrtp_1
X_230_ u_deb.cnt\[7\] _078_ VGND VGND VPWR VPWR _080_ sky130_fd_sc_hd__and2_1
X_359_ net17 net16 VGND VGND VPWR VPWR _170_ sky130_fd_sc_hd__nand2_1
X_428_ clknet_3_0__leaf_clk _000_ net4 VGND VGND VPWR VPWR u_deb.cnt\[0\] sky130_fd_sc_hd__dfrtp_1
Xinput2 mode_sel[0] VGND VGND VPWR VPWR net2 sky130_fd_sc_hd__clkbuf_1
XFILLER_19_108 VGND VGND VPWR VPWR sky130_fd_sc_hd__decap_4
X_213_ u_deb.cnt\[0\] _069_ VGND VGND VPWR VPWR _000_ sky130_fd_sc_hd__and2b_1
XFILLER_33_111 VGND VGND VPWR VPWR sky130_fd_sc_hd__fill_1
XFILLER_24_177 VGND VGND VPWR VPWR sky130_fd_sc_hd__decap_8
XFILLER_30_147 VPWR VGND VPWR VGND sky130_ef_sc_hd__decap_12
XTAP_TAPCELL_ROW_25_161 VGND VPWR sky130_fd_sc_hd__tapvpwrvgnd_1
XFILLER_16_3 VPWR VGND VPWR VGND sky130_ef_sc_hd__decap_12
XFILLER_7_57 VGND VGND VPWR VPWR sky130_fd_sc_hd__fill_1
XFILLER_21_169 VPWR VGND VPWR VGND sky130_ef_sc_hd__decap_12
XFILLER_16_77 VGND VGND VPWR VPWR sky130_fd_sc_hd__decap_6
XFILLER_7_162 VGND VGND VPWR VPWR sky130_fd_sc_hd__decap_6
XFILLER_27_65 VGND VGND VPWR VPWR sky130_fd_sc_hd__decap_4
X_461_ clknet_3_3__leaf_clk _049_ net4 VGND VGND VPWR VPWR net22 sky130_fd_sc_hd__dfrtp_1
X_392_ _148_ u_fsm.state\[2\] _190_ VGND VGND VPWR VPWR _053_ sky130_fd_sc_hd__mux2_1
XFILLER_1_113 VPWR VGND VPWR VGND sky130_ef_sc_hd__decap_12
X_375_ _171_ _181_ _183_ _180_ net18 VGND VGND VPWR VPWR _045_ sky130_fd_sc_hd__a32o_1
X_444_ clknet_3_4__leaf_clk _022_ net4 VGND VGND VPWR VPWR u_tick.cnt\[4\] sky130_fd_sc_hd__dfrtp_1
X_358_ net1 _169_ VGND VGND VPWR VPWR _042_ sky130_fd_sc_hd__nor2_1
X_427_ clknet_3_3__leaf_clk _042_ net4 VGND VGND VPWR VPWR net14 sky130_fd_sc_hd__dfrtp_1
XFILLER_1_15 VPWR VGND VPWR VGND sky130_ef_sc_hd__decap_12
Xinput3 mode_sel[1] VGND VGND VPWR VPWR net3 sky130_fd_sc_hd__clkbuf_1
X_289_ u_fsm.mode_r\[0\] u_fsm.mode_r\[1\] VGND VGND VPWR VPWR _119_ sky130_fd_sc_hd__nand2b_1
XFILLER_28_109 VPWR VGND VPWR VGND sky130_ef_sc_hd__decap_12
XPHY_EDGE_ROW_27_Right_27 VGND VGND VPWR VPWR sky130_fd_sc_hd__decap_3
XPHY_EDGE_ROW_18_Right_18 VGND VGND VPWR VPWR sky130_fd_sc_hd__decap_3
X_212_ sensor_clean sensor_sync VGND VGND VPWR VPWR _069_ sky130_fd_sc_hd__xor2_4
XTAP_TAPCELL_ROW_28_170 VGND VPWR sky130_fd_sc_hd__tapvpwrvgnd_1
XFILLER_18_197 VGND VGND VPWR VPWR sky130_fd_sc_hd__fill_2
XFILLER_24_189 VGND VGND VPWR VPWR sky130_fd_sc_hd__decap_4
XFILLER_30_159 VPWR VGND VPWR VGND sky130_ef_sc_hd__decap_12
XFILLER_30_115 VGND VGND VPWR VPWR sky130_fd_sc_hd__decap_4
XFILLER_21_137 VGND VGND VPWR VPWR sky130_fd_sc_hd__decap_4
XPHY_EDGE_ROW_0_Right_0 VGND VGND VPWR VPWR sky130_fd_sc_hd__decap_3
XFILLER_7_185 VGND VGND VPWR VPWR sky130_fd_sc_hd__decap_4
XFILLER_27_77 VGND VGND VPWR VPWR sky130_fd_sc_hd__decap_8
XFILLER_27_55 VGND VGND VPWR VPWR sky130_fd_sc_hd__fill_1
X_460_ clknet_3_6__leaf_clk _048_ net4 VGND VGND VPWR VPWR net21 sky130_fd_sc_hd__dfrtp_1
X_391_ _135_ u_fsm.state\[1\] _190_ VGND VGND VPWR VPWR _052_ sky130_fd_sc_hd__mux2_1
XFILLER_4_15 VPWR VGND VPWR VGND sky130_ef_sc_hd__decap_12
XFILLER_4_37 VGND VGND VPWR VPWR sky130_fd_sc_hd__fill_2
XFILLER_4_111 VGND VGND VPWR VPWR sky130_fd_sc_hd__decap_3
XFILLER_13_57 VGND VGND VPWR VPWR sky130_fd_sc_hd__decap_4
XFILLER_1_158 VGND VGND VPWR VPWR sky130_fd_sc_hd__fill_1
XFILLER_1_125 VPWR VGND VPWR VGND sky130_ef_sc_hd__decap_12
X_374_ net17 net16 net18 VGND VGND VPWR VPWR _183_ sky130_fd_sc_hd__a21o_1
X_443_ clknet_3_4__leaf_clk _021_ net4 VGND VGND VPWR VPWR u_tick.cnt\[3\] sky130_fd_sc_hd__dfrtp_1
XFILLER_1_169 VGND VGND VPWR VPWR sky130_fd_sc_hd__fill_1
XFILLER_24_34 VPWR VGND VPWR VGND sky130_ef_sc_hd__decap_12
XFILLER_1_27 VGND VGND VPWR VPWR sky130_fd_sc_hd__decap_8
XFILLER_6_3 VPWR VGND VPWR VGND sky130_ef_sc_hd__decap_12
X_288_ u_fsm.mode_r\[0\] u_fsm.mode_r\[1\] VGND VGND VPWR VPWR _118_ sky130_fd_sc_hd__and2b_1
XPHY_EDGE_ROW_23_Left_57 VGND VGND VPWR VPWR sky130_fd_sc_hd__decap_3
Xinput4 rst_n VGND VGND VPWR VPWR net4 sky130_fd_sc_hd__buf_12
X_426_ clknet_3_2__leaf_clk _041_ net4 VGND VGND VPWR VPWR net13 sky130_fd_sc_hd__dfrtp_1
X_357_ bad_inc _158_ net41 VGND VGND VPWR VPWR _169_ sky130_fd_sc_hd__a21oi_1
X_211_ u_fsm.state\[2\] _067_ net24 VGND VGND VPWR VPWR net15 sky130_fd_sc_hd__a21o_1
XFILLER_33_113 VGND VGND VPWR VPWR sky130_fd_sc_hd__fill_2
X_409_ u_fsm.secs\[3\] _199_ _201_ _200_ u_fsm.secs\[4\] VGND VGND VPWR VPWR _061_
+ sky130_fd_sc_hd__a32o_1
XTAP_TAPCELL_ROW_28_171 VGND VPWR sky130_fd_sc_hd__tapvpwrvgnd_1
XFILLER_21_57 VGND VGND VPWR VPWR sky130_fd_sc_hd__decap_4
XFILLER_23_190 VGND VGND VPWR VPWR sky130_fd_sc_hd__decap_8
XFILLER_15_113 VGND VGND VPWR VPWR sky130_fd_sc_hd__decap_8
XFILLER_7_15 VGND VGND VPWR VPWR sky130_fd_sc_hd__decap_4
XPHY_EDGE_ROW_26_Left_60 VGND VGND VPWR VPWR sky130_fd_sc_hd__decap_3
XFILLER_21_127 VGND VGND VPWR VPWR sky130_fd_sc_hd__decap_4
XTAP_TAPCELL_ROW_16_130 VGND VPWR sky130_fd_sc_hd__tapvpwrvgnd_1
XPHY_EDGE_ROW_10_Left_44 VGND VGND VPWR VPWR sky130_fd_sc_hd__decap_3
XFILLER_8_109 VGND VGND VPWR VPWR sky130_fd_sc_hd__decap_8
XFILLER_21_3 VPWR VGND VPWR VGND sky130_ef_sc_hd__decap_12
X_390_ _192_ u_fsm.state\[0\] _190_ VGND VGND VPWR VPWR _051_ sky130_fd_sc_hd__mux2_1
XFILLER_4_27 VGND VGND VPWR VPWR sky130_fd_sc_hd__fill_1
X_373_ _170_ _181_ _182_ _180_ net61 VGND VGND VPWR VPWR _044_ sky130_fd_sc_hd__a32o_1
X_442_ clknet_3_1__leaf_clk _020_ net4 VGND VGND VPWR VPWR u_tick.cnt\[2\] sky130_fd_sc_hd__dfrtp_1
XFILLER_1_137 VGND VGND VPWR VPWR sky130_fd_sc_hd__fill_1
XFILLER_0_181 VPWR VGND VPWR VGND sky130_ef_sc_hd__decap_12
XFILLER_24_46 VPWR VGND VPWR VGND sky130_ef_sc_hd__decap_12
X_287_ _088_ _115_ VGND VGND VPWR VPWR _117_ sky130_fd_sc_hd__or2_1
X_425_ clknet_3_3__leaf_clk _040_ net4 VGND VGND VPWR VPWR net12 sky130_fd_sc_hd__dfrtp_1
X_356_ _159_ _162_ _168_ _161_ net47 VGND VGND VPWR VPWR _041_ sky130_fd_sc_hd__a32o_1
Xinput5 sensor_in VGND VGND VPWR VPWR net5 sky130_fd_sc_hd__clkbuf_1
XFILLER_27_133 VGND VGND VPWR VPWR sky130_fd_sc_hd__decap_3
XFILLER_19_57 VGND VGND VPWR VPWR sky130_fd_sc_hd__decap_4
XFILLER_10_15 VPWR VGND VPWR VGND sky130_ef_sc_hd__decap_12
XFILLER_33_169 VPWR VGND VPWR VGND sky130_ef_sc_hd__decap_12
XFILLER_33_125 VPWR VGND VPWR VGND sky130_ef_sc_hd__decap_12
XTAP_TAPCELL_ROW_28_172 VGND VPWR sky130_fd_sc_hd__tapvpwrvgnd_1
X_408_ u_fsm.secs\[4\] _135_ VGND VGND VPWR VPWR _201_ sky130_fd_sc_hd__and2b_1
X_210_ u_fsm.state\[2\] _067_ VGND VGND VPWR VPWR net6 sky130_fd_sc_hd__and2_1
XFILLER_24_125 VPWR VGND VPWR VGND sky130_ef_sc_hd__decap_12
X_339_ net13 _156_ VGND VGND VPWR VPWR _158_ sky130_fd_sc_hd__and2_1
XFILLER_15_169 VGND VGND VPWR VPWR sky130_fd_sc_hd__fill_2
XFILLER_21_106 VGND VGND VPWR VPWR sky130_fd_sc_hd__fill_2
XFILLER_20_150 VPWR VGND VPWR VGND sky130_ef_sc_hd__decap_12
XFILLER_14_3 VPWR VGND VPWR VGND sky130_ef_sc_hd__decap_12
XFILLER_7_198 VGND VGND VPWR VPWR sky130_fd_sc_hd__fill_1
XFILLER_13_15 VGND VGND VPWR VPWR sky130_fd_sc_hd__decap_4
X_372_ net17 net16 VGND VGND VPWR VPWR _182_ sky130_fd_sc_hd__or2_1
X_441_ clknet_3_1__leaf_clk _019_ net4 VGND VGND VPWR VPWR u_tick.cnt\[1\] sky130_fd_sc_hd__dfrtp_1
XFILLER_0_193 VGND VGND VPWR VPWR sky130_fd_sc_hd__decap_3
XFILLER_24_58 VGND VGND VPWR VPWR sky130_fd_sc_hd__decap_6
XFILLER_5_71 VPWR VGND VPWR VGND sky130_ef_sc_hd__decap_12
XFILLER_30_90 VGND VGND VPWR VPWR sky130_fd_sc_hd__decap_3
X_286_ _088_ _115_ VGND VGND VPWR VPWR _116_ sky130_fd_sc_hd__nor2_1
X_424_ clknet_3_2__leaf_clk _039_ net4 VGND VGND VPWR VPWR net11 sky130_fd_sc_hd__dfrtp_1
X_355_ net13 _156_ VGND VGND VPWR VPWR _168_ sky130_fd_sc_hd__or2_1
XFILLER_10_27 VGND VGND VPWR VPWR sky130_fd_sc_hd__fill_1
XFILLER_27_156 VPWR VGND VPWR VGND sky130_ef_sc_hd__decap_12
XPHY_EDGE_ROW_23_Right_23 VGND VGND VPWR VPWR sky130_fd_sc_hd__decap_3
XPHY_EDGE_ROW_14_Right_14 VGND VGND VPWR VPWR sky130_fd_sc_hd__decap_3
Xclkbuf_3_3__f_clk clknet_0_clk VGND VGND VPWR VPWR clknet_3_3__leaf_clk sky130_fd_sc_hd__clkbuf_16
XFILLER_33_137 VGND VGND VPWR VPWR sky130_fd_sc_hd__decap_3
XPHY_EDGE_ROW_32_Right_32 VGND VGND VPWR VPWR sky130_fd_sc_hd__decap_3
X_407_ u_fsm.secs\[3\] _199_ _200_ VGND VGND VPWR VPWR _060_ sky130_fd_sc_hd__o21a_1
X_269_ _088_ _105_ VGND VGND VPWR VPWR _106_ sky130_fd_sc_hd__nor2_1
XFILLER_24_137 VGND VGND VPWR VPWR sky130_fd_sc_hd__decap_3
XTAP_TAPCELL_ROW_19_140 VGND VPWR sky130_fd_sc_hd__tapvpwrvgnd_1
XFILLER_2_61 VPWR VGND VPWR VGND sky130_ef_sc_hd__decap_12
X_338_ _156_ VGND VGND VPWR VPWR _157_ sky130_fd_sc_hd__inv_2
XFILLER_23_181 VGND VGND VPWR VPWR sky130_fd_sc_hd__decap_4
XFILLER_21_15 VPWR VGND VPWR VGND sky130_ef_sc_hd__decap_12
XFILLER_11_92 VPWR VGND VPWR VGND sky130_ef_sc_hd__decap_12
XFILLER_20_162 VPWR VGND VPWR VGND sky130_ef_sc_hd__decap_12
XFILLER_16_37 VGND VGND VPWR VPWR sky130_fd_sc_hd__fill_2
XFILLER_16_15 VPWR VGND VPWR VGND sky130_ef_sc_hd__decap_12
XFILLER_7_111 VGND VGND VPWR VPWR sky130_fd_sc_hd__fill_1
XFILLER_11_162 VGND VGND VPWR VPWR sky130_fd_sc_hd__decap_6
XPHY_EDGE_ROW_4_Right_4 VGND VGND VPWR VPWR sky130_fd_sc_hd__decap_3
XFILLER_27_69 VGND VGND VPWR VPWR sky130_fd_sc_hd__fill_1
XFILLER_4_29 VGND VGND VPWR VPWR sky130_fd_sc_hd__decap_8
XFILLER_4_103 VGND VGND VPWR VPWR sky130_fd_sc_hd__decap_8
X_371_ _181_ _180_ net16 VGND VGND VPWR VPWR _043_ sky130_fd_sc_hd__mux2_1
X_440_ clknet_3_1__leaf_clk _013_ net4 VGND VGND VPWR VPWR u_tick.cnt\[0\] sky130_fd_sc_hd__dfrtp_1
XFILLER_24_15 VPWR VGND VPWR VGND sky130_ef_sc_hd__decap_12
XFILLER_5_83 VGND VGND VPWR VPWR sky130_fd_sc_hd__fill_2
X_285_ u_fsm.state\[1\] u_fsm.state\[0\] u_fsm.state\[2\] VGND VGND VPWR VPWR _115_
+ sky130_fd_sc_hd__and3b_1
X_423_ clknet_3_2__leaf_clk _038_ net4 VGND VGND VPWR VPWR net10 sky130_fd_sc_hd__dfrtp_1
X_354_ _157_ _162_ _167_ _161_ net46 VGND VGND VPWR VPWR _040_ sky130_fd_sc_hd__a32o_1
XFILLER_27_113 VGND VGND VPWR VPWR sky130_fd_sc_hd__decap_4
XFILLER_19_15 VGND VGND VPWR VPWR sky130_fd_sc_hd__decap_4
XFILLER_4_3 VPWR VGND VPWR VGND sky130_ef_sc_hd__decap_12
XFILLER_33_105 VGND VGND VPWR VPWR sky130_fd_sc_hd__decap_3
X_406_ _131_ _194_ _196_ _088_ VGND VGND VPWR VPWR _200_ sky130_fd_sc_hd__a31oi_1
X_268_ u_tick.cnt\[7\] u_tick.cnt\[9\] u_tick.cnt\[8\] _099_ VGND VGND VPWR VPWR _105_
+ sky130_fd_sc_hd__and4_1
XFILLER_18_135 VGND VGND VPWR VPWR sky130_fd_sc_hd__decap_4
XFILLER_2_73 VGND VGND VPWR VPWR sky130_fd_sc_hd__decap_6
X_337_ net11 net12 _153_ VGND VGND VPWR VPWR _156_ sky130_fd_sc_hd__and3_1
XFILLER_24_105 VPWR VGND VPWR VGND sky130_ef_sc_hd__decap_12
XFILLER_21_27 VPWR VGND VPWR VGND sky130_ef_sc_hd__decap_12
XFILLER_30_119 VGND VGND VPWR VPWR sky130_fd_sc_hd__fill_1
XFILLER_15_149 VPWR VGND VPWR VGND sky130_ef_sc_hd__decap_12
XFILLER_32_15 VPWR VGND VPWR VGND sky130_ef_sc_hd__decap_12
XFILLER_16_27 VGND VGND VPWR VPWR sky130_fd_sc_hd__fill_1
XFILLER_20_174 VGND VGND VPWR VPWR sky130_fd_sc_hd__decap_4
XFILLER_11_141 VGND VGND VPWR VPWR sky130_fd_sc_hd__fill_1
XPHY_EDGE_ROW_14_Left_48 VGND VGND VPWR VPWR sky130_fd_sc_hd__decap_3
XFILLER_7_189 VGND VGND VPWR VPWR sky130_fd_sc_hd__fill_1
XFILLER_27_15 VGND VGND VPWR VPWR sky130_fd_sc_hd__fill_1
XTAP_TAPCELL_ROW_10_106 VGND VPWR sky130_fd_sc_hd__tapvpwrvgnd_1
XFILLER_17_81 VGND VGND VPWR VPWR sky130_fd_sc_hd__decap_6
X_370_ net1 _179_ good_inc VGND VGND VPWR VPWR _181_ sky130_fd_sc_hd__and3b_2
XFILLER_24_27 VGND VGND VPWR VPWR sky130_fd_sc_hd__fill_1
XFILLER_5_51 VGND VGND VPWR VPWR sky130_fd_sc_hd__decap_4
XPHY_EDGE_ROW_17_Left_51 VGND VGND VPWR VPWR sky130_fd_sc_hd__decap_3
X_284_ _088_ _114_ VGND VGND VPWR VPWR _028_ sky130_fd_sc_hd__nor2_1
X_422_ clknet_3_2__leaf_clk _037_ net4 VGND VGND VPWR VPWR net9 sky130_fd_sc_hd__dfrtp_1
X_353_ net11 _153_ net12 VGND VGND VPWR VPWR _167_ sky130_fd_sc_hd__a21o_1
XFILLER_27_169 VPWR VGND VPWR VGND sky130_ef_sc_hd__decap_12
XPHY_EDGE_ROW_2_Left_36 VGND VGND VPWR VPWR sky130_fd_sc_hd__decap_3
XFILLER_10_29 VPWR VGND VPWR VGND sky130_ef_sc_hd__decap_12
X_267_ u_tick.cnt\[7\] u_tick.cnt\[8\] _099_ net57 VGND VGND VPWR VPWR _104_ sky130_fd_sc_hd__a31o_1
X_405_ _088_ _198_ _199_ VGND VGND VPWR VPWR _059_ sky130_fd_sc_hd__nor3_1
XFILLER_18_125 VGND VGND VPWR VPWR sky130_fd_sc_hd__decap_4
XFILLER_18_103 VGND VGND VPWR VPWR sky130_fd_sc_hd__decap_8
X_336_ net11 _153_ VGND VGND VPWR VPWR _155_ sky130_fd_sc_hd__nand2_1
XFILLER_24_117 VGND VGND VPWR VPWR sky130_fd_sc_hd__decap_4
XFILLER_21_39 VGND VGND VPWR VPWR sky130_fd_sc_hd__fill_2
XFILLER_2_85 VGND VGND VPWR VPWR sky130_fd_sc_hd__fill_1
XFILLER_2_41 VGND VGND VPWR VPWR sky130_fd_sc_hd__fill_2
XFILLER_15_139 VGND VGND VPWR VPWR sky130_fd_sc_hd__fill_1
XFILLER_7_19 VGND VGND VPWR VPWR sky130_fd_sc_hd__fill_1
X_319_ u_fsm.state\[2\] _068_ _141_ _064_ _143_ VGND VGND VPWR VPWR _144_ sky130_fd_sc_hd__a221o_1
XFILLER_32_27 VGND VGND VPWR VPWR sky130_fd_sc_hd__fill_1
XTAP_TAPCELL_ROW_22_148 VGND VPWR sky130_fd_sc_hd__tapvpwrvgnd_1
XFILLER_20_197 VGND VGND VPWR VPWR sky130_fd_sc_hd__fill_2
XFILLER_7_113 VGND VGND VPWR VPWR sky130_fd_sc_hd__fill_1
XFILLER_11_186 VGND VGND VPWR VPWR sky130_fd_sc_hd__fill_1
XTAP_TAPCELL_ROW_10_107 VGND VPWR sky130_fd_sc_hd__tapvpwrvgnd_1
XPHY_EDGE_ROW_31_Left_65 VGND VGND VPWR VPWR sky130_fd_sc_hd__decap_3
XTAP_TAPCELL_ROW_4_85 VGND VPWR sky130_fd_sc_hd__tapvpwrvgnd_1
XFILLER_12_3 VPWR VGND VPWR VGND sky130_ef_sc_hd__decap_12
XFILLER_0_141 VGND VGND VPWR VPWR sky130_fd_sc_hd__decap_8
X_421_ clknet_3_2__leaf_clk _036_ net4 VGND VGND VPWR VPWR net8 sky130_fd_sc_hd__dfrtp_2
X_283_ _089_ _113_ _114_ VGND VGND VPWR VPWR _018_ sky130_fd_sc_hd__and3_1
XTAP_TAPCELL_ROW_1_75 VGND VPWR sky130_fd_sc_hd__tapvpwrvgnd_1
X_352_ _155_ _162_ _166_ _161_ net11 VGND VGND VPWR VPWR _039_ sky130_fd_sc_hd__a32o_1
XFILLER_27_126 VGND VGND VPWR VPWR sky130_fd_sc_hd__fill_2
XFILLER_33_118 VGND VGND VPWR VPWR sky130_fd_sc_hd__decap_4
X_266_ net50 _101_ _103_ VGND VGND VPWR VPWR _026_ sky130_fd_sc_hd__o21a_1
X_404_ u_fsm.secs\[2\] _194_ _196_ VGND VGND VPWR VPWR _199_ sky130_fd_sc_hd__and3_1
X_335_ _153_ VGND VGND VPWR VPWR _154_ sky130_fd_sc_hd__inv_2
XPHY_EDGE_ROW_10_Right_10 VGND VGND VPWR VPWR sky130_fd_sc_hd__decap_3
XTAP_TAPCELL_ROW_33_190 VGND VPWR sky130_fd_sc_hd__tapvpwrvgnd_1
X_318_ _065_ _140_ VGND VGND VPWR VPWR _143_ sky130_fd_sc_hd__nor2_1
X_249_ _066_ _090_ _092_ VGND VGND VPWR VPWR _020_ sky130_fd_sc_hd__a21oi_1
XFILLER_14_184 VGND VGND VPWR VPWR sky130_fd_sc_hd__decap_6
XTAP_TAPCELL_ROW_7_96 VGND VPWR sky130_fd_sc_hd__tapvpwrvgnd_1
XTAP_TAPCELL_ROW_22_149 VGND VPWR sky130_fd_sc_hd__tapvpwrvgnd_1
XFILLER_20_187 VGND VGND VPWR VPWR sky130_fd_sc_hd__fill_1
XFILLER_20_132 VGND VGND VPWR VPWR sky130_fd_sc_hd__decap_8
XFILLER_16_29 VGND VGND VPWR VPWR sky130_fd_sc_hd__decap_8
XFILLER_7_169 VGND VGND VPWR VPWR sky130_fd_sc_hd__decap_8
XFILLER_27_39 VGND VGND VPWR VPWR sky130_fd_sc_hd__decap_6
XFILLER_6_191 VGND VGND VPWR VPWR sky130_fd_sc_hd__fill_2
XFILLER_8_85 VPWR VGND VPWR VGND sky130_ef_sc_hd__decap_12
XFILLER_33_82 VGND VGND VPWR VPWR sky130_fd_sc_hd__fill_2
XFILLER_4_139 VGND VGND VPWR VPWR sky130_fd_sc_hd__fill_1
XTAP_TAPCELL_ROW_10_108 VGND VPWR sky130_fd_sc_hd__tapvpwrvgnd_1
XFILLER_13_19 VGND VGND VPWR VPWR sky130_fd_sc_hd__fill_1
XTAP_TAPCELL_ROW_4_86 VGND VPWR sky130_fd_sc_hd__tapvpwrvgnd_1
XPHY_EDGE_ROW_8_Right_8 VGND VGND VPWR VPWR sky130_fd_sc_hd__decap_3
Xhold1 u_sync.ff1 VGND VGND VPWR VPWR net28 sky130_fd_sc_hd__dlygate4sd3_1
XFILLER_28_60 VPWR VGND VPWR VGND sky130_ef_sc_hd__decap_12
XFILLER_0_197 VGND VGND VPWR VPWR sky130_fd_sc_hd__fill_2
XFILLER_0_164 VGND VGND VPWR VPWR sky130_fd_sc_hd__decap_4
XFILLER_0_153 VGND VGND VPWR VPWR sky130_fd_sc_hd__decap_4
XFILLER_24_29 VGND VGND VPWR VPWR sky130_fd_sc_hd__fill_2
XFILLER_30_83 VGND VGND VPWR VPWR sky130_fd_sc_hd__fill_1
X_282_ u_tick.cnt\[13\] u_tick.cnt\[12\] net60 _109_ VGND VGND VPWR VPWR _114_ sky130_fd_sc_hd__nand4_1
XTAP_TAPCELL_ROW_1_76 VGND VPWR sky130_fd_sc_hd__tapvpwrvgnd_1
X_351_ net11 _153_ VGND VGND VPWR VPWR _166_ sky130_fd_sc_hd__or2_1
X_420_ clknet_3_2__leaf_clk _035_ net4 VGND VGND VPWR VPWR net7 sky130_fd_sc_hd__dfrtp_2
X_403_ _194_ _196_ u_fsm.secs\[2\] VGND VGND VPWR VPWR _198_ sky130_fd_sc_hd__a21oi_1
X_334_ net7 net8 net9 net10 VGND VGND VPWR VPWR _153_ sky130_fd_sc_hd__and4_1
X_265_ u_tick.cnt\[8\] _101_ _088_ VGND VGND VPWR VPWR _103_ sky130_fd_sc_hd__a21oi_1
XTAP_TAPCELL_ROW_33_191 VGND VPWR sky130_fd_sc_hd__tapvpwrvgnd_1
X_317_ sensor_clean _134_ _135_ VGND VGND VPWR VPWR _142_ sky130_fd_sc_hd__and3_1
X_248_ _066_ _090_ _089_ VGND VGND VPWR VPWR _092_ sky130_fd_sc_hd__o21ai_1
XFILLER_2_3 VPWR VGND VPWR VGND sky130_ef_sc_hd__decap_12
XTAP_TAPCELL_ROW_7_97 VGND VPWR sky130_fd_sc_hd__tapvpwrvgnd_1
XFILLER_32_29 VPWR VGND VPWR VGND sky130_ef_sc_hd__decap_12
XTAP_TAPCELL_ROW_13_117 VGND VPWR sky130_fd_sc_hd__tapvpwrvgnd_1
XFILLER_11_133 VGND VGND VPWR VPWR sky130_fd_sc_hd__decap_8
XFILLER_6_170 VGND VGND VPWR VPWR sky130_fd_sc_hd__decap_8
XFILLER_8_97 VPWR VGND VPWR VGND sky130_ef_sc_hd__decap_12
XTAP_TAPCELL_ROW_10_109 VGND VPWR sky130_fd_sc_hd__tapvpwrvgnd_1
XTAP_TAPCELL_ROW_4_87 VGND VPWR sky130_fd_sc_hd__tapvpwrvgnd_1
Xhold2 u_fsm.aux\[4\] VGND VGND VPWR VPWR net29 sky130_fd_sc_hd__dlygate4sd3_1
XFILLER_28_72 VPWR VGND VPWR VGND sky130_ef_sc_hd__decap_12
XFILLER_0_110 VGND VGND VPWR VPWR sky130_fd_sc_hd__fill_2
XFILLER_5_65 VGND VGND VPWR VPWR sky130_fd_sc_hd__fill_1
X_281_ u_tick.cnt\[13\] u_tick.cnt\[12\] _109_ u_tick.cnt\[14\] VGND VGND VPWR VPWR
+ _113_ sky130_fd_sc_hd__a31o_1
XFILLER_14_85 VPWR VGND VPWR VGND sky130_ef_sc_hd__decap_12
X_350_ _154_ _162_ _165_ _161_ net49 VGND VGND VPWR VPWR _038_ sky130_fd_sc_hd__a32o_1
XTAP_TAPCELL_ROW_1_77 VGND VPWR sky130_fd_sc_hd__tapvpwrvgnd_1
XFILLER_27_117 VGND VGND VPWR VPWR sky130_fd_sc_hd__fill_1
XFILLER_19_19 VGND VGND VPWR VPWR sky130_fd_sc_hd__fill_1
XFILLER_18_139 VGND VGND VPWR VPWR sky130_fd_sc_hd__fill_1
XFILLER_26_194 VGND VGND VPWR VPWR sky130_fd_sc_hd__fill_2
X_264_ _101_ _102_ VGND VGND VPWR VPWR _025_ sky130_fd_sc_hd__nor2_1
X_402_ u_fsm.secs\[1\] _197_ _194_ VGND VGND VPWR VPWR _058_ sky130_fd_sc_hd__mux2_1
XFILLER_17_150 VPWR VGND VPWR VGND sky130_ef_sc_hd__decap_12
X_333_ net7 net8 net9 VGND VGND VPWR VPWR _152_ sky130_fd_sc_hd__nand3_1
XFILLER_32_197 VGND VGND VPWR VPWR sky130_fd_sc_hd__fill_2
XFILLER_32_164 VPWR VGND VPWR VGND sky130_ef_sc_hd__decap_12
XTAP_TAPCELL_ROW_25_159 VGND VPWR sky130_fd_sc_hd__tapvpwrvgnd_1
XTAP_TAPCELL_ROW_33_192 VGND VPWR sky130_fd_sc_hd__tapvpwrvgnd_1
X_247_ _089_ _090_ _091_ VGND VGND VPWR VPWR _019_ sky130_fd_sc_hd__and3_1
XFILLER_14_197 VGND VGND VPWR VPWR sky130_fd_sc_hd__fill_2
X_316_ _137_ _139_ _141_ tick VGND VGND VPWR VPWR _011_ sky130_fd_sc_hd__and4bb_1
XTAP_TAPCELL_ROW_7_98 VGND VPWR sky130_fd_sc_hd__tapvpwrvgnd_1
XFILLER_28_3 VPWR VGND VPWR VGND sky130_ef_sc_hd__decap_12
XFILLER_20_178 VGND VGND VPWR VPWR sky130_fd_sc_hd__fill_1
XFILLER_22_85 VGND VGND VPWR VPWR sky130_fd_sc_hd__decap_4
XTAP_TAPCELL_ROW_13_118 VGND VPWR sky130_fd_sc_hd__tapvpwrvgnd_1
XFILLER_7_105 VGND VGND VPWR VPWR sky130_fd_sc_hd__decap_6
XFILLER_4_119 VPWR VGND VPWR VGND sky130_ef_sc_hd__decap_12
Xhold3 u_tick.cnt\[0\] VGND VGND VPWR VPWR net30 sky130_fd_sc_hd__dlygate4sd3_1
XTAP_TAPCELL_ROW_4_88 VGND VPWR sky130_fd_sc_hd__tapvpwrvgnd_1
XPHY_EDGE_ROW_9_Left_43 VGND VGND VPWR VPWR sky130_fd_sc_hd__decap_3
XFILLER_0_177 VGND VGND VPWR VPWR sky130_fd_sc_hd__fill_1
XFILLER_5_55 VGND VGND VPWR VPWR sky130_fd_sc_hd__fill_1
XFILLER_10_3 VPWR VGND VPWR VGND sky130_ef_sc_hd__decap_12
XFILLER_30_41 VPWR VGND VPWR VGND sky130_ef_sc_hd__decap_12
X_280_ _111_ _112_ VGND VGND VPWR VPWR _017_ sky130_fd_sc_hd__nor2_1
XFILLER_14_97 VPWR VGND VPWR VGND sky130_ef_sc_hd__decap_12
X_401_ _127_ _196_ _135_ VGND VGND VPWR VPWR _197_ sky130_fd_sc_hd__nor3b_1
X_263_ u_tick.cnt\[7\] _099_ _089_ VGND VGND VPWR VPWR _102_ sky130_fd_sc_hd__o21ai_1
XFILLER_25_63 VGND VGND VPWR VPWR sky130_fd_sc_hd__fill_1
XPHY_EDGE_ROW_22_Left_56 VGND VGND VPWR VPWR sky130_fd_sc_hd__decap_3
XFILLER_18_129 VGND VGND VPWR VPWR sky130_fd_sc_hd__fill_1
X_332_ net7 net8 VGND VGND VPWR VPWR _151_ sky130_fd_sc_hd__nand2_1
XFILLER_32_176 VPWR VGND VPWR VGND sky130_ef_sc_hd__decap_12
XFILLER_17_173 VGND VGND VPWR VPWR sky130_fd_sc_hd__decap_6
XFILLER_17_162 VGND VGND VPWR VPWR sky130_fd_sc_hd__decap_6
XTAP_TAPCELL_ROW_33_193 VGND VPWR sky130_fd_sc_hd__tapvpwrvgnd_1
XFILLER_23_198 VGND VGND VPWR VPWR sky130_fd_sc_hd__fill_1
XFILLER_23_165 VGND VGND VPWR VPWR sky130_fd_sc_hd__decap_3
XTAP_TAPCELL_ROW_16_127 VGND VPWR sky130_fd_sc_hd__tapvpwrvgnd_1
X_315_ sensor_clean _140_ VGND VGND VPWR VPWR _141_ sky130_fd_sc_hd__nor2_1
X_246_ u_tick.cnt\[1\] u_tick.cnt\[0\] VGND VGND VPWR VPWR _091_ sky130_fd_sc_hd__or2_1
XTAP_TAPCELL_ROW_13_119 VGND VPWR sky130_fd_sc_hd__tapvpwrvgnd_1
XFILLER_11_113 VPWR VGND VPWR VGND sky130_ef_sc_hd__decap_12
Xclkbuf_3_4__f_clk clknet_0_clk VGND VGND VPWR VPWR clknet_3_4__leaf_clk sky130_fd_sc_hd__clkbuf_16
X_229_ _078_ _079_ VGND VGND VPWR VPWR _007_ sky130_fd_sc_hd__nor2_1
XFILLER_33_85 VPWR VGND VPWR VGND sky130_ef_sc_hd__decap_12
XFILLER_33_41 VPWR VGND VPWR VGND sky130_ef_sc_hd__decap_12
Xhold4 u_fsm.aux\[5\] VGND VGND VPWR VPWR net31 sky130_fd_sc_hd__dlygate4sd3_1
XFILLER_28_85 VPWR VGND VPWR VGND sky130_ef_sc_hd__decap_12
XPHY_EDGE_ROW_26_Right_26 VGND VGND VPWR VPWR sky130_fd_sc_hd__decap_3
XPHY_EDGE_ROW_17_Right_17 VGND VGND VPWR VPWR sky130_fd_sc_hd__decap_3
XFILLER_30_75 VGND VGND VPWR VPWR sky130_fd_sc_hd__decap_8
XFILLER_30_53 VGND VGND VPWR VPWR sky130_fd_sc_hd__fill_2
XTAP_TAPCELL_ROW_28_169 VGND VPWR sky130_fd_sc_hd__tapvpwrvgnd_1
X_400_ u_fsm.secs\[1\] u_fsm.secs\[0\] VGND VGND VPWR VPWR _196_ sky130_fd_sc_hd__and2_1
X_262_ u_tick.cnt\[7\] _099_ VGND VGND VPWR VPWR _101_ sky130_fd_sc_hd__and2_1
X_331_ net31 _146_ VGND VGND VPWR VPWR _034_ sky130_fd_sc_hd__and2_1
XFILLER_32_188 VGND VGND VPWR VPWR sky130_fd_sc_hd__decap_8
XFILLER_23_144 VGND VGND VPWR VPWR sky130_fd_sc_hd__fill_1
XFILLER_23_111 VGND VGND VPWR VPWR sky130_fd_sc_hd__fill_1
XFILLER_11_55 VGND VGND VPWR VPWR sky130_fd_sc_hd__fill_1
X_314_ u_fsm.state\[0\] u_fsm.state\[2\] u_fsm.state\[1\] VGND VGND VPWR VPWR _140_
+ sky130_fd_sc_hd__or3b_1
XTAP_TAPCELL_ROW_16_128 VGND VPWR sky130_fd_sc_hd__tapvpwrvgnd_1
X_245_ u_tick.cnt\[1\] u_tick.cnt\[0\] VGND VGND VPWR VPWR _090_ sky130_fd_sc_hd__nand2_1
XFILLER_0_3 VPWR VGND VPWR VGND sky130_ef_sc_hd__decap_12
XFILLER_8_56 VGND VGND VPWR VPWR sky130_fd_sc_hd__decap_4
XFILLER_11_125 VGND VGND VPWR VPWR sky130_fd_sc_hd__decap_3
XFILLER_33_3 VPWR VGND VPWR VGND sky130_ef_sc_hd__decap_12
X_228_ net43 _076_ _069_ VGND VGND VPWR VPWR _079_ sky130_fd_sc_hd__o21ai_1
XFILLER_6_184 VGND VGND VPWR VPWR sky130_fd_sc_hd__fill_1
XFILLER_33_97 VGND VGND VPWR VPWR sky130_fd_sc_hd__decap_8
XFILLER_33_53 VGND VGND VPWR VPWR sky130_fd_sc_hd__decap_3
XFILLER_17_43 VGND VGND VPWR VPWR sky130_fd_sc_hd__fill_1
XFILLER_3_121 VPWR VGND VPWR VGND sky130_ef_sc_hd__decap_12
Xhold5 u_fsm.aux\[1\] VGND VGND VPWR VPWR net32 sky130_fd_sc_hd__dlygate4sd3_1
XFILLER_0_113 VPWR VGND VPWR VGND sky130_ef_sc_hd__decap_12
XFILLER_28_97 VPWR VGND VPWR VGND sky130_ef_sc_hd__decap_12
XFILLER_5_57 VGND VGND VPWR VPWR sky130_fd_sc_hd__decap_8
XFILLER_29_161 VGND VGND VPWR VPWR sky130_fd_sc_hd__decap_4
X_476_ clknet_3_5__leaf_clk _062_ net4 VGND VGND VPWR VPWR u_fsm.secs\[5\] sky130_fd_sc_hd__dfrtp_1
XFILLER_27_109 VGND VGND VPWR VPWR sky130_fd_sc_hd__decap_3
XFILLER_26_197 VGND VGND VPWR VPWR sky130_fd_sc_hd__fill_2
XFILLER_25_54 VGND VGND VPWR VPWR sky130_fd_sc_hd__fill_2
X_261_ _099_ _100_ VGND VGND VPWR VPWR _024_ sky130_fd_sc_hd__nor2_1
X_330_ net29 _146_ VGND VGND VPWR VPWR _033_ sky130_fd_sc_hd__and2_1
XFILLER_32_134 VGND VGND VPWR VPWR sky130_fd_sc_hd__decap_6
X_459_ clknet_3_6__leaf_clk _047_ net4 VGND VGND VPWR VPWR net20 sky130_fd_sc_hd__dfrtp_1
XTAP_TAPCELL_ROW_16_129 VGND VPWR sky130_fd_sc_hd__tapvpwrvgnd_1
X_244_ net30 _088_ VGND VGND VPWR VPWR _013_ sky130_fd_sc_hd__nor2_1
X_313_ u_fsm.aux\[3\] u_fsm.aux\[2\] _138_ VGND VGND VPWR VPWR _139_ sky130_fd_sc_hd__nor3_1
XTAP_TAPCELL_ROW_30_176 VGND VPWR sky130_fd_sc_hd__tapvpwrvgnd_1
XFILLER_9_193 VGND VGND VPWR VPWR sky130_fd_sc_hd__decap_3
XFILLER_11_104 VGND VGND VPWR VPWR sky130_fd_sc_hd__decap_8
XFILLER_26_3 VPWR VGND VPWR VGND sky130_ef_sc_hd__decap_12
X_227_ u_deb.cnt\[5\] u_deb.cnt\[4\] u_deb.cnt\[6\] _073_ VGND VGND VPWR VPWR _078_
+ sky130_fd_sc_hd__and4_1
XFILLER_6_141 VGND VGND VPWR VPWR sky130_fd_sc_hd__decap_8
XFILLER_33_65 VGND VGND VPWR VPWR sky130_fd_sc_hd__fill_1
XFILLER_17_55 VGND VGND VPWR VPWR sky130_fd_sc_hd__fill_1
Xhold6 u_deb.cnt\[4\] VGND VGND VPWR VPWR net33 sky130_fd_sc_hd__dlygate4sd3_1
XFILLER_3_133 VPWR VGND VPWR VGND sky130_ef_sc_hd__decap_12
XFILLER_3_166 VGND VGND VPWR VPWR sky130_fd_sc_hd__fill_2
XPHY_EDGE_ROW_3_Right_3 VGND VGND VPWR VPWR sky130_fd_sc_hd__decap_3
XFILLER_0_169 VGND VGND VPWR VPWR sky130_fd_sc_hd__decap_8
XFILLER_0_125 VPWR VGND VPWR VGND sky130_ef_sc_hd__decap_12
XTAP_TAPCELL_ROW_5_90 VGND VPWR sky130_fd_sc_hd__tapvpwrvgnd_1
XFILLER_29_140 VGND VGND VPWR VPWR sky130_fd_sc_hd__fill_1
XFILLER_14_78 VGND VGND VPWR VPWR sky130_fd_sc_hd__decap_6
X_475_ clknet_3_7__leaf_clk _061_ net4 VGND VGND VPWR VPWR u_fsm.secs\[4\] sky130_fd_sc_hd__dfrtp_4
XFILLER_26_121 VGND VGND VPWR VPWR sky130_fd_sc_hd__decap_8
X_260_ net40 _098_ _089_ VGND VGND VPWR VPWR _100_ sky130_fd_sc_hd__o21ai_1
X_458_ clknet_3_7__leaf_clk _046_ net4 VGND VGND VPWR VPWR net19 sky130_fd_sc_hd__dfrtp_1
XTAP_TAPCELL_ROW_19_138 VGND VPWR sky130_fd_sc_hd__tapvpwrvgnd_1
X_389_ net15 _143_ _191_ VGND VGND VPWR VPWR _192_ sky130_fd_sc_hd__or3_1
XFILLER_2_15 VPWR VGND VPWR VGND sky130_ef_sc_hd__decap_12
XFILLER_23_113 VGND VGND VPWR VPWR sky130_fd_sc_hd__decap_8
XTAP_TAPCELL_ROW_2_80 VGND VPWR sky130_fd_sc_hd__tapvpwrvgnd_1
XFILLER_11_57 VPWR VGND VPWR VGND sky130_ef_sc_hd__decap_12
X_243_ u_fsm.state\[2\] _068_ VGND VGND VPWR VPWR _089_ sky130_fd_sc_hd__or2_2
X_312_ u_fsm.aux\[1\] u_fsm.aux\[0\] u_fsm.aux\[4\] u_fsm.aux\[5\] VGND VGND VPWR
+ VPWR _138_ sky130_fd_sc_hd__or4_1
XTAP_TAPCELL_ROW_30_177 VGND VPWR sky130_fd_sc_hd__tapvpwrvgnd_1
XFILLER_22_89 VGND VGND VPWR VPWR sky130_fd_sc_hd__fill_1
XFILLER_19_3 VPWR VGND VPWR VGND sky130_ef_sc_hd__decap_12
X_226_ _076_ _077_ _069_ VGND VGND VPWR VPWR _006_ sky130_fd_sc_hd__and3b_1
XFILLER_6_197 VGND VGND VPWR VPWR sky130_fd_sc_hd__fill_2
XFILLER_3_145 VPWR VGND VPWR VGND sky130_ef_sc_hd__decap_12
Xhold7 u_fsm.aux\[3\] VGND VGND VPWR VPWR net34 sky130_fd_sc_hd__dlygate4sd3_1
XPHY_EDGE_ROW_29_Left_63 VGND VGND VPWR VPWR sky130_fd_sc_hd__decap_3
X_209_ u_fsm.state\[1\] u_fsm.state\[0\] VGND VGND VPWR VPWR _068_ sky130_fd_sc_hd__or2_1
XPHY_EDGE_ROW_13_Left_47 VGND VGND VPWR VPWR sky130_fd_sc_hd__decap_3
XFILLER_0_137 VGND VGND VPWR VPWR sky130_fd_sc_hd__decap_3
XFILLER_5_15 VPWR VGND VPWR VGND sky130_ef_sc_hd__decap_12
XPHY_EDGE_ROW_22_Right_22 VGND VGND VPWR VPWR sky130_fd_sc_hd__decap_3
XPHY_EDGE_ROW_13_Right_13 VGND VGND VPWR VPWR sky130_fd_sc_hd__decap_3
XTAP_TAPCELL_ROW_5_91 VGND VPWR sky130_fd_sc_hd__tapvpwrvgnd_1
XPHY_EDGE_ROW_31_Right_31 VGND VGND VPWR VPWR sky130_fd_sc_hd__decap_3
X_474_ clknet_3_7__leaf_clk _060_ net4 VGND VGND VPWR VPWR u_fsm.secs\[3\] sky130_fd_sc_hd__dfrtp_4
XPHY_EDGE_ROW_16_Left_50 VGND VGND VPWR VPWR sky130_fd_sc_hd__decap_3
XFILLER_6_91 VGND VGND VPWR VPWR sky130_fd_sc_hd__fill_1
XTAP_TAPCELL_ROW_19_139 VGND VPWR sky130_fd_sc_hd__tapvpwrvgnd_1
XFILLER_17_100 VPWR VGND VPWR VGND sky130_ef_sc_hd__decap_12
XFILLER_2_27 VGND VGND VPWR VPWR sky130_fd_sc_hd__fill_1
X_457_ clknet_3_7__leaf_clk _045_ net4 VGND VGND VPWR VPWR net18 sky130_fd_sc_hd__dfrtp_1
XFILLER_23_169 VPWR VGND VPWR VGND sky130_ef_sc_hd__decap_12
XFILLER_23_136 VGND VGND VPWR VPWR sky130_fd_sc_hd__decap_8
XFILLER_23_103 VGND VGND VPWR VPWR sky130_fd_sc_hd__decap_8
X_388_ sensor_clean _135_ _088_ VGND VGND VPWR VPWR _191_ sky130_fd_sc_hd__a21o_1
XTAP_TAPCELL_ROW_2_81 VGND VPWR sky130_fd_sc_hd__tapvpwrvgnd_1
X_242_ u_fsm.state\[2\] _068_ VGND VGND VPWR VPWR _088_ sky130_fd_sc_hd__nor2_4
XPHY_EDGE_ROW_1_Left_35 VGND VGND VPWR VPWR sky130_fd_sc_hd__decap_3
X_311_ u_fsm.aux\[3\] u_fsm.aux\[2\] _136_ VGND VGND VPWR VPWR _137_ sky130_fd_sc_hd__and3_1
XTAP_TAPCELL_ROW_30_178 VGND VPWR sky130_fd_sc_hd__tapvpwrvgnd_1
XFILLER_20_106 VPWR VGND VPWR VGND sky130_ef_sc_hd__decap_12
XFILLER_9_151 VPWR VGND VPWR VGND sky130_ef_sc_hd__decap_12
XTAP_TAPCELL_ROW_21_145 VGND VPWR sky130_fd_sc_hd__tapvpwrvgnd_1
X_225_ u_deb.cnt\[4\] _073_ u_deb.cnt\[5\] VGND VGND VPWR VPWR _077_ sky130_fd_sc_hd__a21o_1
XFILLER_8_15 VPWR VGND VPWR VGND sky130_ef_sc_hd__decap_12
XFILLER_17_57 VPWR VGND VPWR VGND sky130_ef_sc_hd__decap_12
Xhold8 u_deb.cnt\[1\] VGND VGND VPWR VPWR net35 sky130_fd_sc_hd__dlygate4sd3_1
XFILLER_3_157 VGND VGND VPWR VPWR sky130_fd_sc_hd__fill_1
XFILLER_31_3 VPWR VGND VPWR VGND sky130_ef_sc_hd__decap_12
X_208_ u_fsm.state\[1\] u_fsm.state\[0\] VGND VGND VPWR VPWR _067_ sky130_fd_sc_hd__nor2_1
XFILLER_0_149 VGND VGND VPWR VPWR sky130_fd_sc_hd__fill_1
XPHY_EDGE_ROW_30_Left_64 VGND VGND VPWR VPWR sky130_fd_sc_hd__decap_3
XFILLER_5_27 VPWR VGND VPWR VGND sky130_ef_sc_hd__decap_12
X_473_ clknet_3_7__leaf_clk _059_ net4 VGND VGND VPWR VPWR u_fsm.secs\[2\] sky130_fd_sc_hd__dfrtp_2
XFILLER_6_81 VGND VGND VPWR VPWR sky130_fd_sc_hd__decap_3
XFILLER_25_57 VGND VGND VPWR VPWR sky130_fd_sc_hd__decap_6
XFILLER_9_3 VPWR VGND VPWR VGND sky130_ef_sc_hd__decap_12
XFILLER_32_115 VGND VGND VPWR VPWR sky130_fd_sc_hd__fill_1
X_456_ clknet_3_7__leaf_clk _044_ net4 VGND VGND VPWR VPWR net17 sky130_fd_sc_hd__dfrtp_2
X_387_ _189_ _142_ _149_ VGND VGND VPWR VPWR _190_ sky130_fd_sc_hd__or3b_2
XTAP_TAPCELL_ROW_33_187 VGND VPWR sky130_fd_sc_hd__tapvpwrvgnd_1
XFILLER_23_126 VGND VGND VPWR VPWR sky130_fd_sc_hd__decap_3
X_310_ u_fsm.aux\[1\] u_fsm.aux\[0\] u_fsm.aux\[4\] u_fsm.aux\[5\] VGND VGND VPWR
+ VPWR _136_ sky130_fd_sc_hd__and4_1
XFILLER_20_118 VGND VGND VPWR VPWR sky130_fd_sc_hd__fill_1
X_439_ clknet_3_1__leaf_clk _028_ net4 VGND VGND VPWR VPWR tick sky130_fd_sc_hd__dfrtp_1
XFILLER_13_181 VPWR VGND VPWR VGND sky130_ef_sc_hd__decap_12
XFILLER_9_130 VGND VGND VPWR VPWR sky130_fd_sc_hd__fill_1
X_241_ _069_ _086_ _087_ VGND VGND VPWR VPWR _001_ sky130_fd_sc_hd__and3_1
XTAP_TAPCELL_ROW_30_179 VGND VPWR sky130_fd_sc_hd__tapvpwrvgnd_1
XTAP_TAPCELL_ROW_21_146 VGND VPWR sky130_fd_sc_hd__tapvpwrvgnd_1
XFILLER_9_163 VGND VGND VPWR VPWR sky130_fd_sc_hd__fill_2
XFILLER_12_91 VGND VGND VPWR VPWR sky130_fd_sc_hd__fill_1
X_224_ u_deb.cnt\[5\] u_deb.cnt\[4\] _073_ VGND VGND VPWR VPWR _076_ sky130_fd_sc_hd__and3_1
XFILLER_8_27 VGND VGND VPWR VPWR sky130_fd_sc_hd__fill_1
XTAP_TAPCELL_ROW_12_113 VGND VPWR sky130_fd_sc_hd__tapvpwrvgnd_1
XFILLER_33_57 VGND VGND VPWR VPWR sky130_fd_sc_hd__decap_8
XFILLER_17_69 VPWR VGND VPWR VGND sky130_ef_sc_hd__decap_12
Xhold9 _002_ VGND VGND VPWR VPWR net36 sky130_fd_sc_hd__dlygate4sd3_1
XFILLER_24_3 VPWR VGND VPWR VGND sky130_ef_sc_hd__decap_12
X_207_ u_fsm.state\[2\] u_fsm.state\[0\] u_fsm.state\[1\] VGND VGND VPWR VPWR net24
+ sky130_fd_sc_hd__and3b_1
XFILLER_5_39 VPWR VGND VPWR VGND sky130_ef_sc_hd__decap_12
XFILLER_14_37 VGND VGND VPWR VPWR sky130_fd_sc_hd__fill_1
XFILLER_14_15 VPWR VGND VPWR VGND sky130_ef_sc_hd__decap_12
XPHY_EDGE_ROW_7_Right_7 VGND VGND VPWR VPWR sky130_fd_sc_hd__decap_3
XFILLER_29_132 VGND VGND VPWR VPWR sky130_fd_sc_hd__decap_8
XFILLER_29_121 VGND VGND VPWR VPWR sky130_fd_sc_hd__fill_2
X_472_ clknet_3_7__leaf_clk _058_ net4 VGND VGND VPWR VPWR u_fsm.secs\[1\] sky130_fd_sc_hd__dfrtp_1
XFILLER_6_60 VGND VGND VPWR VPWR sky130_fd_sc_hd__fill_1
X_455_ clknet_3_7__leaf_clk _043_ net4 VGND VGND VPWR VPWR net16 sky130_fd_sc_hd__dfrtp_2
XFILLER_17_179 VGND VGND VPWR VPWR sky130_fd_sc_hd__fill_1
XFILLER_17_113 VGND VGND VPWR VPWR sky130_fd_sc_hd__decap_8
X_386_ tick _147_ _088_ _065_ VGND VGND VPWR VPWR _189_ sky130_fd_sc_hd__a2bb2o_1
XFILLER_2_29 VPWR VGND VPWR VGND sky130_ef_sc_hd__decap_12
XTAP_TAPCELL_ROW_33_188 VGND VPWR sky130_fd_sc_hd__tapvpwrvgnd_1
XFILLER_11_49 VGND VGND VPWR VPWR sky130_fd_sc_hd__decap_6
XTAP_TAPCELL_ROW_24_155 VGND VPWR sky130_fd_sc_hd__tapvpwrvgnd_1
XFILLER_14_138 VGND VGND VPWR VPWR sky130_fd_sc_hd__fill_2
X_240_ u_deb.cnt\[10\] _084_ VGND VGND VPWR VPWR _087_ sky130_fd_sc_hd__or2_1
X_369_ good_inc _179_ net1 VGND VGND VPWR VPWR _180_ sky130_fd_sc_hd__a21oi_4
X_438_ clknet_3_2__leaf_clk _001_ net4 VGND VGND VPWR VPWR u_deb.cnt\[10\] sky130_fd_sc_hd__dfrtp_1
XFILLER_9_120 VGND VGND VPWR VPWR sky130_fd_sc_hd__fill_2
XFILLER_22_15 VPWR VGND VPWR VGND sky130_ef_sc_hd__decap_12
XTAP_TAPCELL_ROW_21_147 VGND VPWR sky130_fd_sc_hd__tapvpwrvgnd_1
XTAP_TAPCELL_ROW_12_114 VGND VPWR sky130_fd_sc_hd__tapvpwrvgnd_1
X_223_ net33 _073_ _075_ VGND VGND VPWR VPWR _005_ sky130_fd_sc_hd__a21oi_1
XFILLER_10_141 VPWR VGND VPWR VGND sky130_ef_sc_hd__decap_12
XFILLER_12_81 VGND VGND VPWR VPWR sky130_fd_sc_hd__decap_3
XFILLER_6_112 VGND VGND VPWR VPWR sky130_fd_sc_hd__fill_1
XFILLER_6_178 VGND VGND VPWR VPWR sky130_fd_sc_hd__fill_1
XFILLER_33_69 VGND VGND VPWR VPWR sky130_fd_sc_hd__fill_1
XFILLER_17_15 VPWR VGND VPWR VGND sky130_ef_sc_hd__decap_12
XFILLER_23_91 VPWR VGND VPWR VGND sky130_ef_sc_hd__decap_12
X_206_ net62 VGND VGND VPWR VPWR _066_ sky130_fd_sc_hd__inv_2
XFILLER_17_3 VPWR VGND VPWR VGND sky130_ef_sc_hd__decap_12
Xclkbuf_3_5__f_clk clknet_0_clk VGND VGND VPWR VPWR clknet_3_5__leaf_clk sky130_fd_sc_hd__clkbuf_16
XFILLER_30_15 VPWR VGND VPWR VGND sky130_ef_sc_hd__decap_12
X_471_ clknet_3_6__leaf_clk _057_ net4 VGND VGND VPWR VPWR u_fsm.secs\[0\] sky130_fd_sc_hd__dfrtp_1
XFILLER_14_27 VGND VGND VPWR VPWR sky130_fd_sc_hd__fill_1
XFILLER_25_15 VPWR VGND VPWR VGND sky130_ef_sc_hd__decap_12
XFILLER_32_106 VGND VGND VPWR VPWR sky130_fd_sc_hd__fill_2
XFILLER_17_169 VGND VGND VPWR VPWR sky130_fd_sc_hd__fill_1
X_385_ net1 _188_ VGND VGND VPWR VPWR _050_ sky130_fd_sc_hd__nor2_1
X_454_ clknet_3_1__leaf_clk _018_ net4 VGND VGND VPWR VPWR u_tick.cnt\[14\] sky130_fd_sc_hd__dfrtp_1
XTAP_TAPCELL_ROW_33_189 VGND VPWR sky130_fd_sc_hd__tapvpwrvgnd_1
XFILLER_16_180 VGND VGND VPWR VPWR sky130_fd_sc_hd__fill_2
XFILLER_11_39 VGND VGND VPWR VPWR sky130_fd_sc_hd__fill_2
XTAP_TAPCELL_ROW_24_156 VGND VPWR sky130_fd_sc_hd__tapvpwrvgnd_1
XFILLER_22_161 VGND VGND VPWR VPWR sky130_fd_sc_hd__decap_3
XFILLER_14_117 VGND VGND VPWR VPWR sky130_fd_sc_hd__decap_3
X_299_ _127_ _122_ VGND VGND VPWR VPWR _128_ sky130_fd_sc_hd__and2b_1
X_368_ net23 _177_ VGND VGND VPWR VPWR _179_ sky130_fd_sc_hd__nand2_1
XFILLER_13_161 VGND VGND VPWR VPWR sky130_fd_sc_hd__decap_6
XFILLER_3_73 VPWR VGND VPWR VGND sky130_ef_sc_hd__decap_12
X_437_ clknet_3_0__leaf_clk _010_ net4 VGND VGND VPWR VPWR u_deb.cnt\[9\] sky130_fd_sc_hd__dfrtp_1
XFILLER_9_110 VGND VGND VPWR VPWR sky130_fd_sc_hd__fill_2
XPHY_EDGE_ROW_29_Right_29 VGND VGND VPWR VPWR sky130_fd_sc_hd__decap_3
XFILLER_22_27 VGND VGND VPWR VPWR sky130_fd_sc_hd__fill_1
XPHY_EDGE_ROW_5_Left_39 VGND VGND VPWR VPWR sky130_fd_sc_hd__decap_3
XTAP_TAPCELL_ROW_12_115 VGND VPWR sky130_fd_sc_hd__tapvpwrvgnd_1
X_222_ u_deb.cnt\[4\] _073_ _069_ VGND VGND VPWR VPWR _075_ sky130_fd_sc_hd__o21ai_1
XFILLER_8_29 VPWR VGND VPWR VGND sky130_ef_sc_hd__decap_12
XFILLER_10_153 VPWR VGND VPWR VGND sky130_ef_sc_hd__decap_12
XFILLER_10_175 VPWR VGND VPWR VGND sky130_ef_sc_hd__decap_12
XFILLER_10_197 VGND VGND VPWR VPWR sky130_fd_sc_hd__fill_2
XFILLER_33_15 VPWR VGND VPWR VGND sky130_ef_sc_hd__decap_12
XFILLER_17_27 VPWR VGND VPWR VGND sky130_ef_sc_hd__decap_12
X_205_ sensor_clean VGND VGND VPWR VPWR _065_ sky130_fd_sc_hd__inv_2
XFILLER_0_85 VGND VGND VPWR VPWR sky130_fd_sc_hd__decap_6
XFILLER_0_41 VPWR VGND VPWR VGND sky130_ef_sc_hd__decap_12
XFILLER_28_48 VPWR VGND VPWR VGND sky130_ef_sc_hd__decap_12
XFILLER_28_37 VGND VGND VPWR VPWR sky130_fd_sc_hd__fill_1
XFILLER_28_15 VPWR VGND VPWR VGND sky130_ef_sc_hd__decap_12
XPHY_EDGE_ROW_8_Left_42 VGND VGND VPWR VPWR sky130_fd_sc_hd__decap_3
XFILLER_30_27 VGND VGND VPWR VPWR sky130_fd_sc_hd__fill_1
XFILLER_29_101 VGND VGND VPWR VPWR sky130_fd_sc_hd__decap_8
X_470_ clknet_3_6__leaf_clk _012_ net4 VGND VGND VPWR VPWR good_inc sky130_fd_sc_hd__dfrtp_1
XFILLER_20_82 VGND VGND VPWR VPWR sky130_fd_sc_hd__fill_2
XFILLER_25_27 VPWR VGND VPWR VGND sky130_ef_sc_hd__decap_12
X_453_ clknet_3_4__leaf_clk _017_ net4 VGND VGND VPWR VPWR u_tick.cnt\[13\] sky130_fd_sc_hd__dfrtp_1
X_384_ good_inc _177_ net42 VGND VGND VPWR VPWR _188_ sky130_fd_sc_hd__a21oi_1
XFILLER_15_71 VGND VGND VPWR VPWR sky130_fd_sc_hd__fill_1
XFILLER_11_18 VGND VGND VPWR VPWR sky130_fd_sc_hd__fill_1
XTAP_TAPCELL_ROW_24_157 VGND VPWR sky130_fd_sc_hd__tapvpwrvgnd_1
XFILLER_22_195 VGND VGND VPWR VPWR sky130_fd_sc_hd__fill_1
XFILLER_7_3 VPWR VGND VPWR VGND sky130_ef_sc_hd__decap_12
X_298_ u_fsm.secs\[1\] u_fsm.secs\[0\] VGND VGND VPWR VPWR _127_ sky130_fd_sc_hd__nor2_1
XPHY_EDGE_ROW_21_Left_55 VGND VGND VPWR VPWR sky130_fd_sc_hd__decap_3
X_367_ _177_ VGND VGND VPWR VPWR _178_ sky130_fd_sc_hd__inv_2
XTAP_TAPCELL_ROW_15_124 VGND VPWR sky130_fd_sc_hd__tapvpwrvgnd_1
XFILLER_3_41 VGND VGND VPWR VPWR sky130_fd_sc_hd__fill_1
X_436_ clknet_3_1__leaf_clk _009_ net4 VGND VGND VPWR VPWR u_deb.cnt\[8\] sky130_fd_sc_hd__dfrtp_1
XFILLER_3_85 VGND VGND VPWR VPWR sky130_fd_sc_hd__decap_3
XTAP_TAPCELL_ROW_12_116 VGND VPWR sky130_fd_sc_hd__tapvpwrvgnd_1
X_221_ _073_ _074_ _069_ VGND VGND VPWR VPWR _004_ sky130_fd_sc_hd__and3b_1
XFILLER_10_165 VGND VGND VPWR VPWR sky130_fd_sc_hd__fill_2
XFILLER_10_187 VGND VGND VPWR VPWR sky130_fd_sc_hd__decap_6
XFILLER_17_39 VGND VGND VPWR VPWR sky130_fd_sc_hd__decap_4
X_419_ clknet_3_1__leaf_clk net28 net4 VGND VGND VPWR VPWR sensor_sync sky130_fd_sc_hd__dfrtp_2
XFILLER_33_27 VGND VGND VPWR VPWR sky130_fd_sc_hd__fill_1
X_204_ tick VGND VGND VPWR VPWR _064_ sky130_fd_sc_hd__inv_2
XFILLER_2_161 VGND VGND VPWR VPWR sky130_fd_sc_hd__decap_4
XFILLER_0_53 VGND VGND VPWR VPWR sky130_fd_sc_hd__decap_3
XFILLER_28_27 VGND VGND VPWR VPWR sky130_fd_sc_hd__fill_1
XFILLER_22_3 VPWR VGND VPWR VGND sky130_ef_sc_hd__decap_12
XFILLER_14_29 VGND VGND VPWR VPWR sky130_fd_sc_hd__decap_8
XFILLER_29_113 VGND VGND VPWR VPWR sky130_fd_sc_hd__decap_8
XFILLER_26_138 VGND VGND VPWR VPWR sky130_fd_sc_hd__fill_2
XFILLER_26_105 VGND VGND VPWR VPWR sky130_fd_sc_hd__decap_4
XFILLER_6_41 VGND VGND VPWR VPWR sky130_fd_sc_hd__decap_4
XFILLER_6_85 VGND VGND VPWR VPWR sky130_fd_sc_hd__decap_6
XTAP_TAPCELL_ROW_27_166 VGND VPWR sky130_fd_sc_hd__tapvpwrvgnd_1
XFILLER_25_39 VGND VGND VPWR VPWR sky130_fd_sc_hd__decap_8
X_452_ clknet_3_4__leaf_clk _016_ net4 VGND VGND VPWR VPWR u_tick.cnt\[12\] sky130_fd_sc_hd__dfrtp_1
XFILLER_17_138 VPWR VGND VPWR VGND sky130_ef_sc_hd__decap_12
X_383_ _178_ _181_ _187_ _180_ net38 VGND VGND VPWR VPWR _049_ sky130_fd_sc_hd__a32o_1
XFILLER_31_163 VGND VGND VPWR VPWR sky130_fd_sc_hd__decap_4
XFILLER_31_82 VGND VGND VPWR VPWR sky130_fd_sc_hd__fill_1
XTAP_TAPCELL_ROW_24_158 VGND VPWR sky130_fd_sc_hd__tapvpwrvgnd_1
X_297_ u_fsm.secs\[1\] _118_ _120_ u_fsm.secs\[3\] u_fsm.secs\[2\] VGND VGND VPWR
+ VPWR _126_ sky130_fd_sc_hd__a221o_1
XFILLER_26_93 VPWR VGND VPWR VGND sky130_ef_sc_hd__decap_12
X_366_ net22 _175_ VGND VGND VPWR VPWR _177_ sky130_fd_sc_hd__and2_1
XTAP_TAPCELL_ROW_15_125 VGND VPWR sky130_fd_sc_hd__tapvpwrvgnd_1
X_435_ clknet_3_0__leaf_clk _008_ net4 VGND VGND VPWR VPWR u_deb.cnt\[7\] sky130_fd_sc_hd__dfrtp_1
XFILLER_22_29 VGND VGND VPWR VPWR sky130_fd_sc_hd__decap_4
XFILLER_3_53 VGND VGND VPWR VPWR sky130_fd_sc_hd__decap_3
X_220_ u_deb.cnt\[3\] _071_ VGND VGND VPWR VPWR _074_ sky130_fd_sc_hd__or2_1
X_349_ net7 net8 net9 net10 VGND VGND VPWR VPWR _165_ sky130_fd_sc_hd__a31o_1
XFILLER_5_181 VGND VGND VPWR VPWR sky130_fd_sc_hd__fill_1
X_418_ clknet_3_1__leaf_clk net5 net4 VGND VGND VPWR VPWR u_sync.ff1 sky130_fd_sc_hd__dfrtp_1
XFILLER_23_61 VGND VGND VPWR VPWR sky130_fd_sc_hd__fill_1
X_203_ u_fsm.state\[0\] VGND VGND VPWR VPWR _063_ sky130_fd_sc_hd__inv_2
XFILLER_0_98 VPWR VGND VPWR VGND sky130_ef_sc_hd__decap_12
XFILLER_0_76 VGND VGND VPWR VPWR sky130_fd_sc_hd__decap_8
XFILLER_30_29 VPWR VGND VPWR VGND sky130_ef_sc_hd__decap_12
XFILLER_15_3 VPWR VGND VPWR VGND sky130_ef_sc_hd__decap_12
XFILLER_20_51 VGND VGND VPWR VPWR sky130_fd_sc_hd__decap_8
XTAP_TAPCELL_ROW_27_167 VGND VPWR sky130_fd_sc_hd__tapvpwrvgnd_1
X_451_ clknet_3_4__leaf_clk _015_ net4 VGND VGND VPWR VPWR u_tick.cnt\[11\] sky130_fd_sc_hd__dfrtp_1
XTAP_TAPCELL_ROW_18_134 VGND VPWR sky130_fd_sc_hd__tapvpwrvgnd_1
X_382_ net22 _175_ VGND VGND VPWR VPWR _187_ sky130_fd_sc_hd__or2_1
XFILLER_22_131 VGND VGND VPWR VPWR sky130_fd_sc_hd__fill_2
XFILLER_14_109 VGND VGND VPWR VPWR sky130_fd_sc_hd__decap_8
X_296_ u_fsm.secs\[3\] u_fsm.secs\[2\] VGND VGND VPWR VPWR _125_ sky130_fd_sc_hd__or2_1
XFILLER_22_197 VGND VGND VPWR VPWR sky130_fd_sc_hd__fill_2
X_365_ _175_ VGND VGND VPWR VPWR _176_ sky130_fd_sc_hd__inv_2
XTAP_TAPCELL_ROW_15_126 VGND VPWR sky130_fd_sc_hd__tapvpwrvgnd_1
XFILLER_13_142 VGND VGND VPWR VPWR sky130_fd_sc_hd__fill_1
X_434_ clknet_3_0__leaf_clk _007_ net4 VGND VGND VPWR VPWR u_deb.cnt\[6\] sky130_fd_sc_hd__dfrtp_1
XFILLER_9_113 VGND VGND VPWR VPWR sky130_fd_sc_hd__fill_2
XFILLER_12_85 VGND VGND VPWR VPWR sky130_fd_sc_hd__decap_6
XFILLER_12_41 VPWR VGND VPWR VGND sky130_ef_sc_hd__decap_12
XPHY_EDGE_ROW_25_Right_25 VGND VGND VPWR VPWR sky130_fd_sc_hd__decap_3
X_279_ u_tick.cnt\[13\] u_tick.cnt\[12\] _109_ _088_ VGND VGND VPWR VPWR _112_ sky130_fd_sc_hd__a31o_1
XPHY_EDGE_ROW_16_Right_16 VGND VGND VPWR VPWR sky130_fd_sc_hd__decap_3
X_348_ _152_ _162_ _164_ _161_ net9 VGND VGND VPWR VPWR _037_ sky130_fd_sc_hd__a32o_1
X_417_ clknet_3_2__leaf_clk _034_ net4 VGND VGND VPWR VPWR u_fsm.aux\[5\] sky130_fd_sc_hd__dfrtp_1
XFILLER_33_29 VPWR VGND VPWR VGND sky130_ef_sc_hd__decap_12
XFILLER_2_141 VPWR VGND VPWR VGND sky130_ef_sc_hd__decap_12
XFILLER_28_29 VGND VGND VPWR VPWR sky130_fd_sc_hd__decap_8
Xclkbuf_3_0__f_clk clknet_0_clk VGND VGND VPWR VPWR clknet_3_0__leaf_clk sky130_fd_sc_hd__clkbuf_16
XPHY_EDGE_ROW_2_Right_2 VGND VGND VPWR VPWR sky130_fd_sc_hd__decap_3
XFILLER_20_96 VGND VGND VPWR VPWR sky130_fd_sc_hd__fill_2
XFILLER_20_74 VGND VGND VPWR VPWR sky130_fd_sc_hd__decap_8
XFILLER_20_41 VGND VGND VPWR VPWR sky130_fd_sc_hd__decap_6
XFILLER_31_51 VGND VGND VPWR VPWR sky130_fd_sc_hd__decap_4
XTAP_TAPCELL_ROW_27_168 VGND VPWR sky130_fd_sc_hd__tapvpwrvgnd_1
X_450_ clknet_3_5__leaf_clk _014_ net4 VGND VGND VPWR VPWR u_tick.cnt\[10\] sky130_fd_sc_hd__dfrtp_1
XFILLER_25_162 VGND VGND VPWR VPWR sky130_fd_sc_hd__decap_6
X_381_ _176_ _181_ _186_ _180_ net45 VGND VGND VPWR VPWR _048_ sky130_fd_sc_hd__a32o_1
XTAP_TAPCELL_ROW_18_135 VGND VPWR sky130_fd_sc_hd__tapvpwrvgnd_1
XFILLER_16_195 VGND VGND VPWR VPWR sky130_fd_sc_hd__fill_1
X_433_ clknet_3_0__leaf_clk _006_ net4 VGND VGND VPWR VPWR u_deb.cnt\[5\] sky130_fd_sc_hd__dfrtp_1
XTAP_TAPCELL_ROW_9_103 VGND VPWR sky130_fd_sc_hd__tapvpwrvgnd_1
X_295_ u_fsm.secs\[5\] _123_ _124_ _116_ VGND VGND VPWR VPWR net25 sky130_fd_sc_hd__o31a_1
X_364_ net21 net20 _172_ VGND VGND VPWR VPWR _175_ sky130_fd_sc_hd__and3_1
XPHY_EDGE_ROW_25_Left_59 VGND VGND VPWR VPWR sky130_fd_sc_hd__decap_3
X_278_ u_tick.cnt\[12\] _109_ net58 VGND VGND VPWR VPWR _111_ sky130_fd_sc_hd__a21oi_1
XTAP_TAPCELL_ROW_20_141 VGND VPWR sky130_fd_sc_hd__tapvpwrvgnd_1
XFILLER_12_53 VGND VGND VPWR VPWR sky130_fd_sc_hd__decap_8
X_347_ net7 net8 net9 VGND VGND VPWR VPWR _164_ sky130_fd_sc_hd__a21o_1
XFILLER_5_3 VPWR VGND VPWR VGND sky130_ef_sc_hd__decap_12
X_416_ clknet_3_2__leaf_clk _033_ net4 VGND VGND VPWR VPWR u_fsm.aux\[4\] sky130_fd_sc_hd__dfrtp_1
XFILLER_3_109 VGND VGND VPWR VPWR sky130_fd_sc_hd__decap_3
XFILLER_2_197 VGND VGND VPWR VPWR sky130_fd_sc_hd__fill_2
XFILLER_2_131 VGND VGND VPWR VPWR sky130_fd_sc_hd__decap_8
XFILLER_9_98 VPWR VGND VPWR VGND sky130_ef_sc_hd__decap_12
XFILLER_18_85 VGND VGND VPWR VPWR sky130_fd_sc_hd__decap_4
XPHY_EDGE_ROW_28_Left_62 VGND VGND VPWR VPWR sky130_fd_sc_hd__decap_3
XFILLER_29_149 VPWR VGND VPWR VGND sky130_ef_sc_hd__decap_12
XPHY_EDGE_ROW_12_Left_46 VGND VGND VPWR VPWR sky130_fd_sc_hd__decap_3
XFILLER_20_3 VPWR VGND VPWR VGND sky130_ef_sc_hd__decap_12
XFILLER_31_74 VGND VGND VPWR VPWR sky130_fd_sc_hd__decap_8
X_380_ net20 _172_ net21 VGND VGND VPWR VPWR _186_ sky130_fd_sc_hd__a21o_1
Xoutput6 net6 VGND VGND VPWR VPWR alarm_short sky130_fd_sc_hd__buf_1
XTAP_TAPCELL_ROW_2_78 VGND VPWR sky130_fd_sc_hd__tapvpwrvgnd_1
XFILLER_31_177 VGND VGND VPWR VPWR sky130_fd_sc_hd__fill_2
XFILLER_31_122 VPWR VGND VPWR VGND sky130_ef_sc_hd__decap_12
XTAP_TAPCELL_ROW_18_136 VGND VPWR sky130_fd_sc_hd__tapvpwrvgnd_1
XFILLER_16_141 VPWR VGND VPWR VGND sky130_ef_sc_hd__decap_12
XFILLER_16_130 VGND VGND VPWR VPWR sky130_fd_sc_hd__decap_8
.ends
